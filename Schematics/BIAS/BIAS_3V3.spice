* NGSPICE file created from BIAS_3v3.ext - technology: gf180mcuD

.subckt nfet_03v3_V2UEBS a_396_n517# a_980_n425# a_n980_n517# a_n740_n425# a_n1084_n425#
+ a_n1324_n517# a_292_n425# a_n292_n517# a_n52_n425# a_1324_n425# a_n1412_n425# a_636_n425#
+ a_n396_n425# a_n636_n517# a_740_n517# a_n1550_n611# a_52_n517# a_1084_n517#
X0 a_636_n425# a_396_n517# a_292_n425# a_n1550_n611# nfet_03v3 ad=1.105p pd=4.77u as=1.105p ps=4.77u w=4.25u l=1.2u
X1 a_980_n425# a_740_n517# a_636_n425# a_n1550_n611# nfet_03v3 ad=1.105p pd=4.77u as=1.105p ps=4.77u w=4.25u l=1.2u
X2 a_1324_n425# a_1084_n517# a_980_n425# a_n1550_n611# nfet_03v3 ad=1.87p pd=9.38u as=1.105p ps=4.77u w=4.25u l=1.2u
X3 a_n396_n425# a_n636_n517# a_n740_n425# a_n1550_n611# nfet_03v3 ad=1.105p pd=4.77u as=1.105p ps=4.77u w=4.25u l=1.2u
X4 a_n740_n425# a_n980_n517# a_n1084_n425# a_n1550_n611# nfet_03v3 ad=1.105p pd=4.77u as=1.105p ps=4.77u w=4.25u l=1.2u
X5 a_n1084_n425# a_n1324_n517# a_n1412_n425# a_n1550_n611# nfet_03v3 ad=1.105p pd=4.77u as=1.87p ps=9.38u w=4.25u l=1.2u
X6 a_n52_n425# a_n292_n517# a_n396_n425# a_n1550_n611# nfet_03v3 ad=1.105p pd=4.77u as=1.105p ps=4.77u w=4.25u l=1.2u
X7 a_292_n425# a_52_n517# a_n52_n425# a_n1550_n611# nfet_03v3 ad=1.105p pd=4.77u as=1.105p ps=4.77u w=4.25u l=1.2u
C0 a_740_n517# a_1084_n517# 0.05997f
C1 a_980_n425# a_636_n425# 0.13084f
C2 a_n740_n425# a_n396_n425# 0.13084f
C3 a_n740_n425# a_n1084_n425# 0.13084f
C4 a_n292_n517# a_n396_n425# 0.10021f
C5 a_n980_n517# a_n1084_n425# 0.10021f
C6 a_1324_n425# a_1084_n517# 0.10021f
C7 a_740_n517# a_396_n517# 0.05997f
C8 a_n1324_n517# a_n980_n517# 0.05997f
C9 a_n292_n517# a_n52_n425# 0.10021f
C10 a_52_n517# a_n52_n425# 0.10021f
C11 a_n636_n517# a_n740_n425# 0.10021f
C12 a_292_n425# a_52_n517# 0.10021f
C13 a_n636_n517# a_n292_n517# 0.05997f
C14 a_n980_n517# a_n636_n517# 0.05997f
C15 a_636_n425# a_396_n517# 0.10021f
C16 a_636_n425# a_740_n517# 0.10021f
C17 a_292_n425# a_396_n517# 0.10021f
C18 a_n1412_n425# a_n1084_n425# 0.13084f
C19 a_980_n425# a_1084_n517# 0.10021f
C20 a_n1324_n517# a_n1084_n425# 0.10021f
C21 a_n396_n425# a_n52_n425# 0.13084f
C22 a_n1324_n517# a_n1412_n425# 0.10021f
C23 a_n292_n517# a_52_n517# 0.05997f
C24 a_n980_n517# a_n740_n425# 0.10021f
C25 a_n636_n517# a_n396_n425# 0.10021f
C26 a_980_n425# a_740_n517# 0.10021f
C27 a_636_n425# a_292_n425# 0.13084f
C28 a_292_n425# a_n52_n425# 0.13084f
C29 a_980_n425# a_1324_n425# 0.13084f
C30 a_52_n517# a_396_n517# 0.05997f
C31 a_1324_n425# a_n1550_n611# 0.93081f
C32 a_980_n425# a_n1550_n611# 0.90023f
C33 a_636_n425# a_n1550_n611# 0.87362f
C34 a_292_n425# a_n1550_n611# 0.87304f
C35 a_n52_n425# a_n1550_n611# 0.87292f
C36 a_n396_n425# a_n1550_n611# 0.87304f
C37 a_n740_n425# a_n1550_n611# 0.87362f
C38 a_n1084_n425# a_n1550_n611# 0.90023f
C39 a_n1412_n425# a_n1550_n611# 0.93081f
.ends

.subckt nfet_03v3_KVBDJ8 a_1324_n575# a_n1412_n575# a_n396_n575# a_636_n575# a_n636_n667#
+ a_740_n667# a_n1550_n761# a_52_n667# a_1084_n667# a_396_n667# a_980_n575# a_n980_n667#
+ a_n740_n575# a_n1084_n575# a_n1324_n667# a_292_n575# a_n292_n667# a_n52_n575#
X0 a_292_n575# a_52_n667# a_n52_n575# a_n1550_n761# nfet_03v3 ad=1.495p pd=6.27u as=1.495p ps=6.27u w=5.75u l=1.2u
X1 a_636_n575# a_396_n667# a_292_n575# a_n1550_n761# nfet_03v3 ad=1.495p pd=6.27u as=1.495p ps=6.27u w=5.75u l=1.2u
X2 a_980_n575# a_740_n667# a_636_n575# a_n1550_n761# nfet_03v3 ad=1.495p pd=6.27u as=1.495p ps=6.27u w=5.75u l=1.2u
X3 a_1324_n575# a_1084_n667# a_980_n575# a_n1550_n761# nfet_03v3 ad=2.53p pd=12.38u as=1.495p ps=6.27u w=5.75u l=1.2u
X4 a_n396_n575# a_n636_n667# a_n740_n575# a_n1550_n761# nfet_03v3 ad=1.495p pd=6.27u as=1.495p ps=6.27u w=5.75u l=1.2u
X5 a_n740_n575# a_n980_n667# a_n1084_n575# a_n1550_n761# nfet_03v3 ad=1.495p pd=6.27u as=1.495p ps=6.27u w=5.75u l=1.2u
X6 a_n1084_n575# a_n1324_n667# a_n1412_n575# a_n1550_n761# nfet_03v3 ad=1.495p pd=6.27u as=2.53p ps=12.38u w=5.75u l=1.2u
X7 a_n52_n575# a_n292_n667# a_n396_n575# a_n1550_n761# nfet_03v3 ad=1.495p pd=6.27u as=1.495p ps=6.27u w=5.75u l=1.2u
C0 a_636_n575# a_292_n575# 0.17724f
C1 a_52_n667# a_292_n575# 0.13575f
C2 a_n740_n575# a_n1084_n575# 0.17724f
C3 a_52_n667# a_n292_n667# 0.05997f
C4 a_n740_n575# a_n980_n667# 0.13575f
C5 a_n740_n575# a_n636_n667# 0.13575f
C6 a_52_n667# a_n52_n575# 0.13575f
C7 a_980_n575# a_1084_n667# 0.13575f
C8 a_636_n575# a_740_n667# 0.13575f
C9 a_n1412_n575# a_n1324_n667# 0.13575f
C10 a_n292_n667# a_n396_n575# 0.13575f
C11 a_n636_n667# a_n396_n575# 0.13575f
C12 a_n1084_n575# a_n1324_n667# 0.13575f
C13 a_980_n575# a_1324_n575# 0.17724f
C14 a_n1084_n575# a_n1412_n575# 0.17724f
C15 a_292_n575# a_396_n667# 0.13575f
C16 a_n1324_n667# a_n980_n667# 0.05997f
C17 a_n52_n575# a_n396_n575# 0.17724f
C18 a_980_n575# a_636_n575# 0.17724f
C19 a_980_n575# a_740_n667# 0.13575f
C20 a_n740_n575# a_n396_n575# 0.17724f
C21 a_1324_n575# a_1084_n667# 0.13575f
C22 a_n1084_n575# a_n980_n667# 0.13575f
C23 a_n292_n667# a_n636_n667# 0.05997f
C24 a_740_n667# a_1084_n667# 0.05997f
C25 a_n636_n667# a_n980_n667# 0.05997f
C26 a_636_n575# a_396_n667# 0.13575f
C27 a_52_n667# a_396_n667# 0.05997f
C28 a_740_n667# a_396_n667# 0.05997f
C29 a_292_n575# a_n52_n575# 0.17724f
C30 a_n292_n667# a_n52_n575# 0.13575f
C31 a_1324_n575# a_n1550_n761# 1.09004f
C32 a_980_n575# a_n1550_n761# 0.90144f
C33 a_636_n575# a_n1550_n761# 0.87482f
C34 a_292_n575# a_n1550_n761# 0.87425f
C35 a_n52_n575# a_n1550_n761# 0.87413f
C36 a_n396_n575# a_n1550_n761# 0.87425f
C37 a_n740_n575# a_n1550_n761# 0.87482f
C38 a_n1084_n575# a_n1550_n761# 0.90144f
C39 a_n1412_n575# a_n1550_n761# 1.09004f
.ends

.subckt pfet_03v3_E7RYUB a_2356_n1028# a_n2356_n1120# a_n2700_n1120# a_740_24# a_n1324_24#
+ a_2460_n1120# a_2460_24# a_2012_116# a_n2700_24# a_n980_24# a_n2460_n1028# a_n2788_n1028#
+ a_2700_116# a_52_24# a_2116_24# a_1772_24# a_396_24# a_n52_n1028# a_636_n1028# a_1324_n1028#
+ a_1428_n1120# a_n1324_n1120# a_n636_24# a_292_n1028# a_740_n1120# a_396_n1120# a_n636_n1120#
+ a_n2356_24# a_1084_n1120# a_n396_116# a_n292_n1120# a_1428_24# a_n1428_n1028# a_1668_n1028#
+ a_n1084_116# a_980_n1028# a_n740_n1028# a_n1084_n1028# a_n1668_n1120# a_292_116#
+ a_n1668_24# a_n396_n1028# a_1772_n1120# a_n980_n1120# a_n1772_116# a_980_116# a_n740_116#
+ a_n52_116# a_n1772_n1028# a_n2460_116# a_n2788_116# a_2012_n1028# a_n2012_n1120#
+ a_1668_116# a_n2012_24# a_2116_n1120# a_n1428_116# a_n292_24# w_n2950_n1238# a_636_116#
+ a_52_n1120# a_n2116_n1028# a_2356_116# a_1324_116# a_1084_24# a_2700_n1028# a_n2116_116#
+ VSUBS
X0 a_n1772_116# a_n2012_24# a_n2116_116# w_n2950_n1238# pfet_03v3 ad=1.1856p pd=5.08u as=1.1856p ps=5.08u w=4.56u l=1.2u
X1 a_1324_116# a_1084_24# a_980_116# w_n2950_n1238# pfet_03v3 ad=1.1856p pd=5.08u as=1.1856p ps=5.08u w=4.56u l=1.2u
X2 a_1668_116# a_1428_24# a_1324_116# w_n2950_n1238# pfet_03v3 ad=1.1856p pd=5.08u as=1.1856p ps=5.08u w=4.56u l=1.2u
X3 a_n1428_n1028# a_n1668_n1120# a_n1772_n1028# w_n2950_n1238# pfet_03v3 ad=1.1856p pd=5.08u as=1.1856p ps=5.08u w=4.56u l=1.2u
X4 a_2012_n1028# a_1772_n1120# a_1668_n1028# w_n2950_n1238# pfet_03v3 ad=1.1856p pd=5.08u as=1.1856p ps=5.08u w=4.56u l=1.2u
X5 a_636_116# a_396_24# a_292_116# w_n2950_n1238# pfet_03v3 ad=1.1856p pd=5.08u as=1.1856p ps=5.08u w=4.56u l=1.2u
X6 a_980_116# a_740_24# a_636_116# w_n2950_n1238# pfet_03v3 ad=1.1856p pd=5.08u as=1.1856p ps=5.08u w=4.56u l=1.2u
X7 a_n1428_116# a_n1668_24# a_n1772_116# w_n2950_n1238# pfet_03v3 ad=1.1856p pd=5.08u as=1.1856p ps=5.08u w=4.56u l=1.2u
X8 a_n2116_n1028# a_n2356_n1120# a_n2460_n1028# w_n2950_n1238# pfet_03v3 ad=1.1856p pd=5.08u as=1.1856p ps=5.08u w=4.56u l=1.2u
X9 a_2700_n1028# a_2460_n1120# a_2356_n1028# w_n2950_n1238# pfet_03v3 ad=2.0064p pd=10u as=1.1856p ps=5.08u w=4.56u l=1.2u
X10 a_n396_n1028# a_n636_n1120# a_n740_n1028# w_n2950_n1238# pfet_03v3 ad=1.1856p pd=5.08u as=1.1856p ps=5.08u w=4.56u l=1.2u
X11 a_n1084_116# a_n1324_24# a_n1428_116# w_n2950_n1238# pfet_03v3 ad=1.1856p pd=5.08u as=1.1856p ps=5.08u w=4.56u l=1.2u
X12 a_2700_116# a_2460_24# a_2356_116# w_n2950_n1238# pfet_03v3 ad=2.0064p pd=10u as=1.1856p ps=5.08u w=4.56u l=1.2u
X13 a_n740_116# a_n980_24# a_n1084_116# w_n2950_n1238# pfet_03v3 ad=1.1856p pd=5.08u as=1.1856p ps=5.08u w=4.56u l=1.2u
X14 a_n52_n1028# a_n292_n1120# a_n396_n1028# w_n2950_n1238# pfet_03v3 ad=1.1856p pd=5.08u as=1.1856p ps=5.08u w=4.56u l=1.2u
X15 a_n2460_116# a_n2700_24# a_n2788_116# w_n2950_n1238# pfet_03v3 ad=1.1856p pd=5.08u as=2.0064p ps=10u w=4.56u l=1.2u
X16 a_n1084_n1028# a_n1324_n1120# a_n1428_n1028# w_n2950_n1238# pfet_03v3 ad=1.1856p pd=5.08u as=1.1856p ps=5.08u w=4.56u l=1.2u
X17 a_980_n1028# a_740_n1120# a_636_n1028# w_n2950_n1238# pfet_03v3 ad=1.1856p pd=5.08u as=1.1856p ps=5.08u w=4.56u l=1.2u
X18 a_n52_116# a_n292_24# a_n396_116# w_n2950_n1238# pfet_03v3 ad=1.1856p pd=5.08u as=1.1856p ps=5.08u w=4.56u l=1.2u
X19 a_2356_116# a_2116_24# a_2012_116# w_n2950_n1238# pfet_03v3 ad=1.1856p pd=5.08u as=1.1856p ps=5.08u w=4.56u l=1.2u
X20 a_n1772_n1028# a_n2012_n1120# a_n2116_n1028# w_n2950_n1238# pfet_03v3 ad=1.1856p pd=5.08u as=1.1856p ps=5.08u w=4.56u l=1.2u
X21 a_n396_116# a_n636_24# a_n740_116# w_n2950_n1238# pfet_03v3 ad=1.1856p pd=5.08u as=1.1856p ps=5.08u w=4.56u l=1.2u
X22 a_292_116# a_52_24# a_n52_116# w_n2950_n1238# pfet_03v3 ad=1.1856p pd=5.08u as=1.1856p ps=5.08u w=4.56u l=1.2u
X23 a_292_n1028# a_52_n1120# a_n52_n1028# w_n2950_n1238# pfet_03v3 ad=1.1856p pd=5.08u as=1.1856p ps=5.08u w=4.56u l=1.2u
X24 a_n2116_116# a_n2356_24# a_n2460_116# w_n2950_n1238# pfet_03v3 ad=1.1856p pd=5.08u as=1.1856p ps=5.08u w=4.56u l=1.2u
X25 a_n2460_n1028# a_n2700_n1120# a_n2788_n1028# w_n2950_n1238# pfet_03v3 ad=1.1856p pd=5.08u as=2.0064p ps=10u w=4.56u l=1.2u
X26 a_1668_n1028# a_1428_n1120# a_1324_n1028# w_n2950_n1238# pfet_03v3 ad=1.1856p pd=5.08u as=1.1856p ps=5.08u w=4.56u l=1.2u
X27 a_2012_116# a_1772_24# a_1668_116# w_n2950_n1238# pfet_03v3 ad=1.1856p pd=5.08u as=1.1856p ps=5.08u w=4.56u l=1.2u
X28 a_636_n1028# a_396_n1120# a_292_n1028# w_n2950_n1238# pfet_03v3 ad=1.1856p pd=5.08u as=1.1856p ps=5.08u w=4.56u l=1.2u
X29 a_2356_n1028# a_2116_n1120# a_2012_n1028# w_n2950_n1238# pfet_03v3 ad=1.1856p pd=5.08u as=1.1856p ps=5.08u w=4.56u l=1.2u
X30 a_n740_n1028# a_n980_n1120# a_n1084_n1028# w_n2950_n1238# pfet_03v3 ad=1.1856p pd=5.08u as=1.1856p ps=5.08u w=4.56u l=1.2u
X31 a_1324_n1028# a_1084_n1120# a_980_n1028# w_n2950_n1238# pfet_03v3 ad=1.1856p pd=5.08u as=1.1856p ps=5.08u w=4.56u l=1.2u
C0 a_2012_n1028# a_2116_n1120# 0.10756f
C1 a_2356_n1028# a_2356_116# 0.0083f
C2 a_2700_n1028# a_2356_n1028# 0.14043f
C3 a_740_24# a_1084_24# 0.05997f
C4 a_1772_24# w_n2950_n1238# 0.5702f
C5 a_n2356_24# a_n2356_n1120# 0.22367f
C6 a_396_24# w_n2950_n1238# 0.56952f
C7 a_n636_n1120# a_n396_n1028# 0.10756f
C8 a_n1668_n1120# w_n2950_n1238# 0.5699f
C9 w_n2950_n1238# a_n2116_116# 0.18846f
C10 a_980_n1028# a_636_n1028# 0.14043f
C11 a_n1668_24# a_n1772_116# 0.10756f
C12 a_n1084_116# w_n2950_n1238# 0.18844f
C13 a_740_n1120# a_980_n1028# 0.10756f
C14 a_292_116# w_n2950_n1238# 0.18844f
C15 a_1772_n1120# a_2116_n1120# 0.05997f
C16 a_n1668_n1120# a_n2012_n1120# 0.05997f
C17 a_n2356_24# a_n2460_116# 0.10756f
C18 a_n1084_n1028# w_n2950_n1238# 0.18844f
C19 a_n2012_24# a_n2356_24# 0.05997f
C20 a_2012_116# w_n2950_n1238# 0.18846f
C21 a_n52_n1028# a_52_n1120# 0.10756f
C22 a_n2788_n1028# a_n2700_n1120# 0.10756f
C23 a_2460_n1120# a_2116_n1120# 0.05997f
C24 a_980_116# a_980_n1028# 0.0083f
C25 a_n1668_n1120# a_n1428_n1028# 0.10756f
C26 a_1772_24# a_1668_116# 0.10756f
C27 a_n2788_n1028# a_n2788_116# 0.0083f
C28 a_n1428_n1028# a_n1084_n1028# 0.14043f
C29 a_n2116_n1028# w_n2950_n1238# 0.18846f
C30 a_n1772_116# w_n2950_n1238# 0.18845f
C31 a_52_n1120# a_396_n1120# 0.05997f
C32 a_1772_24# a_2116_24# 0.05997f
C33 a_n292_n1120# a_n636_n1120# 0.05997f
C34 a_52_24# w_n2950_n1238# 0.56952f
C35 a_n2460_n1028# a_n2788_n1028# 0.14043f
C36 w_n2950_n1238# a_n52_116# 0.18844f
C37 a_n2116_n1028# a_n2012_n1120# 0.10756f
C38 a_1772_24# a_1428_24# 0.05997f
C39 a_n740_n1028# a_n1084_n1028# 0.14043f
C40 a_2012_116# a_2356_116# 0.14043f
C41 a_2012_116# a_1668_116# 0.14043f
C42 a_2012_116# a_2116_24# 0.10756f
C43 a_396_n1120# a_636_n1028# 0.10756f
C44 a_740_n1120# a_396_n1120# 0.05997f
C45 a_n396_n1028# a_n396_116# 0.0083f
C46 a_292_n1028# a_292_116# 0.0083f
C47 a_n1668_24# w_n2950_n1238# 0.5699f
C48 a_n292_n1120# a_n292_24# 0.22367f
C49 a_740_n1120# a_636_n1028# 0.10756f
C50 a_n2700_24# a_n2460_116# 0.10756f
C51 a_n1324_n1120# a_n1324_24# 0.22367f
C52 w_n2950_n1238# a_2460_24# 0.61307f
C53 a_n2460_n1028# a_n2116_n1028# 0.14043f
C54 a_1428_n1120# w_n2950_n1238# 0.5699f
C55 w_n2950_n1238# a_n2012_n1120# 0.5702f
C56 a_2012_n1028# a_2356_n1028# 0.14043f
C57 a_n2356_24# a_n2116_116# 0.10756f
C58 a_n1428_n1028# w_n2950_n1238# 0.18845f
C59 a_2356_116# a_2460_24# 0.10756f
C60 a_n1428_116# a_n1324_24# 0.10756f
C61 a_2356_116# w_n2950_n1238# 0.1885f
C62 a_2700_n1028# w_n2950_n1238# 0.59437f
C63 a_n740_n1028# w_n2950_n1238# 0.18844f
C64 w_n2950_n1238# a_1668_116# 0.18845f
C65 a_740_24# a_740_n1120# 0.22367f
C66 a_n1324_n1120# a_n980_n1120# 0.05997f
C67 a_2116_24# a_2460_24# 0.05997f
C68 a_2460_n1120# a_2356_n1028# 0.10756f
C69 a_2116_24# w_n2950_n1238# 0.57109f
C70 a_n2700_n1120# w_n2950_n1238# 0.61307f
C71 w_n2950_n1238# a_1428_24# 0.5699f
C72 a_2356_n1028# a_2116_n1120# 0.10756f
C73 a_1428_n1120# a_1428_24# 0.22367f
C74 a_n636_n1120# a_n980_n1120# 0.05997f
C75 a_1772_24# a_1772_n1120# 0.22367f
C76 a_1324_116# w_n2950_n1238# 0.18845f
C77 a_n2788_116# w_n2950_n1238# 0.59437f
C78 a_980_116# a_740_24# 0.10756f
C79 a_2012_n1028# a_2012_116# 0.0083f
C80 a_292_n1028# w_n2950_n1238# 0.18844f
C81 a_n2460_n1028# w_n2950_n1238# 0.1885f
C82 a_1084_24# w_n2950_n1238# 0.56958f
C83 a_2356_116# a_2116_24# 0.10756f
C84 a_n1324_24# a_n980_24# 0.05997f
C85 a_1668_116# a_1428_24# 0.10756f
C86 a_396_n1120# a_396_24# 0.22367f
C87 a_1324_116# a_1668_116# 0.14043f
C88 a_636_116# a_636_n1028# 0.0083f
C89 a_n396_n1028# w_n2950_n1238# 0.18844f
C90 a_2700_116# a_2460_24# 0.10756f
C91 a_1084_n1120# w_n2950_n1238# 0.56958f
C92 w_n2950_n1238# a_2700_116# 0.59437f
C93 a_1084_n1120# a_1428_n1120# 0.05997f
C94 a_1324_116# a_1428_24# 0.10756f
C95 a_n1324_24# a_n1084_116# 0.10756f
C96 a_n2460_n1028# a_n2700_n1120# 0.10756f
C97 a_n52_n1028# a_n52_116# 0.0083f
C98 a_n980_24# a_n980_n1120# 0.22367f
C99 a_1084_24# a_1428_24# 0.05997f
C100 a_980_116# a_636_116# 0.14043f
C101 a_n2356_24# w_n2950_n1238# 0.57109f
C102 a_52_24# a_52_n1120# 0.22367f
C103 a_1324_116# a_1084_24# 0.10756f
C104 a_n636_n1120# a_n636_24# 0.22367f
C105 a_n396_n1028# a_n740_n1028# 0.14043f
C106 a_2356_116# a_2700_116# 0.14043f
C107 a_n1324_n1120# a_n1668_n1120# 0.05997f
C108 a_n2460_116# a_n2116_116# 0.14043f
C109 a_2700_n1028# a_2700_116# 0.0083f
C110 a_n292_n1120# w_n2950_n1238# 0.56952f
C111 a_980_n1028# w_n2950_n1238# 0.18844f
C112 a_n2012_24# a_n2116_116# 0.10756f
C113 a_n1324_n1120# a_n1084_n1028# 0.10756f
C114 a_2012_n1028# w_n2950_n1238# 0.18846f
C115 a_n396_116# a_n292_24# 0.10756f
C116 a_n740_116# a_n980_24# 0.10756f
C117 a_740_24# a_636_116# 0.10756f
C118 a_n740_116# a_n396_116# 0.14043f
C119 a_n2116_n1028# a_n2356_n1120# 0.10756f
C120 a_1668_n1028# w_n2950_n1238# 0.18845f
C121 a_n636_24# a_n292_24# 0.05997f
C122 a_n1084_n1028# a_n980_n1120# 0.10756f
C123 a_1428_n1120# a_1668_n1028# 0.10756f
C124 a_n1668_n1120# a_n1772_n1028# 0.10756f
C125 a_1772_n1120# w_n2950_n1238# 0.5702f
C126 a_1428_n1120# a_1772_n1120# 0.05997f
C127 a_740_24# a_396_24# 0.05997f
C128 a_n740_116# a_n636_24# 0.10756f
C129 a_1084_n1120# a_1084_24# 0.22367f
C130 a_n1428_116# a_n1084_116# 0.14043f
C131 a_n2012_24# a_n1772_116# 0.10756f
C132 a_n52_n1028# w_n2950_n1238# 0.18844f
C133 a_n1668_24# a_n1324_24# 0.05997f
C134 a_2460_n1120# a_2460_24# 0.22367f
C135 a_1324_n1028# w_n2950_n1238# 0.18845f
C136 a_2460_n1120# w_n2950_n1238# 0.61307f
C137 a_1428_n1120# a_1324_n1028# 0.10756f
C138 a_52_n1120# w_n2950_n1238# 0.56952f
C139 a_n740_116# a_n1084_116# 0.14043f
C140 a_n980_24# a_n636_24# 0.05997f
C141 a_2116_n1120# w_n2950_n1238# 0.57109f
C142 a_1668_n1028# a_1668_116# 0.0083f
C143 a_n396_116# a_n636_24# 0.10756f
C144 a_n2116_n1028# a_n1772_n1028# 0.14043f
C145 a_n1772_116# a_n1772_n1028# 0.0083f
C146 a_396_n1120# w_n2950_n1238# 0.56952f
C147 a_n2700_24# w_n2950_n1238# 0.61307f
C148 a_n1428_116# a_n1772_116# 0.14043f
C149 a_n1668_24# a_n2012_24# 0.05997f
C150 a_n1324_24# w_n2950_n1238# 0.56958f
C151 a_636_n1028# w_n2950_n1238# 0.18844f
C152 a_2700_n1028# a_2460_n1120# 0.10756f
C153 a_n980_24# a_n1084_116# 0.10756f
C154 a_740_n1120# w_n2950_n1238# 0.56952f
C155 a_52_24# a_n292_24# 0.05997f
C156 a_n52_116# a_n292_24# 0.10756f
C157 a_n2356_n1120# w_n2950_n1238# 0.57109f
C158 a_636_116# a_396_24# 0.10756f
C159 a_n2356_n1120# a_n2012_n1120# 0.05997f
C160 a_n292_n1120# a_n396_n1028# 0.10756f
C161 a_2116_n1120# a_2116_24# 0.22367f
C162 a_n1324_n1120# w_n2950_n1238# 0.56958f
C163 a_n2460_116# w_n2950_n1238# 0.1885f
C164 a_292_116# a_636_116# 0.14043f
C165 a_n1428_116# a_n1668_24# 0.10756f
C166 a_1324_116# a_1324_n1028# 0.0083f
C167 a_1084_n1120# a_980_n1028# 0.10756f
C168 a_980_116# w_n2950_n1238# 0.18844f
C169 a_n2012_24# w_n2950_n1238# 0.5702f
C170 a_292_n1028# a_n52_n1028# 0.14043f
C171 a_n2012_24# a_n2012_n1120# 0.22367f
C172 a_292_116# a_396_24# 0.10756f
C173 a_n2700_24# a_n2700_n1120# 0.22367f
C174 a_n636_n1120# w_n2950_n1238# 0.56952f
C175 a_292_n1028# a_52_n1120# 0.10756f
C176 a_n396_116# a_n52_116# 0.14043f
C177 a_n980_n1120# w_n2950_n1238# 0.56952f
C178 a_2012_116# a_1772_24# 0.10756f
C179 a_n1084_n1028# a_n1084_116# 0.0083f
C180 a_n1324_n1120# a_n1428_n1028# 0.10756f
C181 a_292_n1028# a_396_n1120# 0.10756f
C182 a_n2700_24# a_n2788_116# 0.10756f
C183 w_n2950_n1238# a_n1772_n1028# 0.18845f
C184 a_n1772_n1028# a_n2012_n1120# 0.10756f
C185 a_n1428_116# w_n2950_n1238# 0.18845f
C186 a_n2356_n1120# a_n2700_n1120# 0.05997f
C187 a_740_24# w_n2950_n1238# 0.56952f
C188 a_n52_n1028# a_n396_n1028# 0.14043f
C189 a_292_n1028# a_636_n1028# 0.14043f
C190 a_1084_n1120# a_1324_n1028# 0.10756f
C191 a_52_24# a_396_24# 0.05997f
C192 a_n2116_n1028# a_n2116_116# 0.0083f
C193 w_n2950_n1238# a_n292_24# 0.56952f
C194 a_n1772_116# a_n2116_116# 0.14043f
C195 a_n636_n1120# a_n740_n1028# 0.10756f
C196 a_n1428_n1028# a_n1772_n1028# 0.14043f
C197 a_n740_116# w_n2950_n1238# 0.18844f
C198 a_292_116# a_52_24# 0.10756f
C199 a_n740_n1028# a_n980_n1120# 0.10756f
C200 a_n2460_n1028# a_n2356_n1120# 0.10756f
C201 a_292_116# a_n52_116# 0.14043f
C202 a_n2460_116# a_n2788_116# 0.14043f
C203 a_n1428_116# a_n1428_n1028# 0.0083f
C204 a_980_116# a_1324_116# 0.14043f
C205 a_n2460_n1028# a_n2460_116# 0.0083f
C206 a_2012_n1028# a_1668_n1028# 0.14043f
C207 a_980_116# a_1084_24# 0.10756f
C208 a_2356_n1028# w_n2950_n1238# 0.1885f
C209 a_2012_n1028# a_1772_n1120# 0.10756f
C210 a_n980_24# w_n2950_n1238# 0.56952f
C211 a_n292_n1120# a_n52_n1028# 0.10756f
C212 a_n396_116# w_n2950_n1238# 0.18844f
C213 a_980_n1028# a_1324_n1028# 0.14043f
C214 a_1084_n1120# a_740_n1120# 0.05997f
C215 a_n1668_24# a_n1668_n1120# 0.22367f
C216 a_1772_n1120# a_1668_n1028# 0.10756f
C217 a_n2788_n1028# w_n2950_n1238# 0.59437f
C218 a_n292_n1120# a_52_n1120# 0.05997f
C219 a_n2356_24# a_n2700_24# 0.05997f
C220 a_n740_116# a_n740_n1028# 0.0083f
C221 a_52_24# a_n52_116# 0.10756f
C222 a_n636_24# w_n2950_n1238# 0.56952f
C223 a_636_116# w_n2950_n1238# 0.18844f
C224 a_1668_n1028# a_1324_n1028# 0.14043f
C225 a_2700_n1028# VSUBS 0.01781f
C226 a_2356_n1028# VSUBS 0.03047f
C227 a_2012_n1028# VSUBS 0.02532f
C228 a_1668_n1028# VSUBS 0.02532f
C229 a_1324_n1028# VSUBS 0.02532f
C230 a_980_n1028# VSUBS 0.02532f
C231 a_636_n1028# VSUBS 0.02532f
C232 a_292_n1028# VSUBS 0.02532f
C233 a_n52_n1028# VSUBS 0.02532f
C234 a_n396_n1028# VSUBS 0.02532f
C235 a_n740_n1028# VSUBS 0.02532f
C236 a_n1084_n1028# VSUBS 0.02532f
C237 a_n1428_n1028# VSUBS 0.02532f
C238 a_n1772_n1028# VSUBS 0.02532f
C239 a_n2116_n1028# VSUBS 0.02532f
C240 a_n2460_n1028# VSUBS 0.03047f
C241 a_n2788_n1028# VSUBS 0.01781f
C242 a_2700_116# VSUBS 0.01781f
C243 a_2356_116# VSUBS 0.03047f
C244 a_2012_116# VSUBS 0.02532f
C245 a_1668_116# VSUBS 0.02532f
C246 a_1324_116# VSUBS 0.02532f
C247 a_980_116# VSUBS 0.02532f
C248 a_636_116# VSUBS 0.02532f
C249 a_292_116# VSUBS 0.02532f
C250 a_n52_116# VSUBS 0.02532f
C251 a_n396_116# VSUBS 0.02532f
C252 a_n740_116# VSUBS 0.02532f
C253 a_n1084_116# VSUBS 0.02532f
C254 a_n1428_116# VSUBS 0.02532f
C255 a_n1772_116# VSUBS 0.02532f
C256 a_n2116_116# VSUBS 0.02532f
C257 a_n2460_116# VSUBS 0.03047f
C258 a_n2788_116# VSUBS 0.01781f
C259 w_n2950_n1238# VSUBS 46.4165f
.ends

.subckt nfet_03v3_NVCL9G a_n208_n425# a_n346_n611# a_120_n425# a_n120_n517#
X0 a_120_n425# a_n120_n517# a_n208_n425# a_n346_n611# nfet_03v3 ad=1.87p pd=9.38u as=1.87p ps=9.38u w=4.25u l=1.2u
C0 a_n120_n517# a_120_n425# 0.10021f
C1 a_n120_n517# a_n208_n425# 0.10021f
C2 a_120_n425# a_n208_n425# 0.13084f
C3 a_120_n425# a_n346_n611# 0.95778f
C4 a_n208_n425# a_n346_n611# 0.95778f
.ends

.subckt pfet_03v3_NFMJS6 a_n120_24# w_n370_n1238# a_120_n1028# a_n208_n1028# a_n120_n1120#
+ a_120_116# a_n208_116# VSUBS
X0 a_120_n1028# a_n120_n1120# a_n208_n1028# w_n370_n1238# pfet_03v3 ad=2.0064p pd=10u as=2.0064p ps=10u w=4.56u l=1.2u
X1 a_120_116# a_n120_24# a_n208_116# w_n370_n1238# pfet_03v3 ad=2.0064p pd=10u as=2.0064p ps=10u w=4.56u l=1.2u
C0 a_n208_n1028# a_n120_n1120# 0.10756f
C1 a_n208_n1028# a_120_n1028# 0.14043f
C2 w_n370_n1238# a_n120_n1120# 0.65662f
C3 a_n120_n1120# a_n120_24# 0.22367f
C4 w_n370_n1238# a_120_n1028# 0.59442f
C5 a_120_116# a_120_n1028# 0.0083f
C6 a_n208_n1028# w_n370_n1238# 0.59442f
C7 a_n208_n1028# a_n208_116# 0.0083f
C8 a_120_n1028# a_n120_n1120# 0.10756f
C9 a_120_116# w_n370_n1238# 0.59442f
C10 w_n370_n1238# a_n208_116# 0.59442f
C11 a_120_116# a_n208_116# 0.14043f
C12 w_n370_n1238# a_n120_24# 0.65662f
C13 a_120_116# a_n120_24# 0.10756f
C14 a_n208_116# a_n120_24# 0.10756f
C15 a_120_n1028# VSUBS 0.02297f
C16 a_n208_n1028# VSUBS 0.02297f
C17 a_120_116# VSUBS 0.02297f
C18 a_n208_116# VSUBS 0.02297f
C19 w_n370_n1238# VSUBS 6.50257f
.ends

.subckt nfet_03v3_W7XH28 a_n208_n575# a_n346_n761# a_120_n575# a_n120_n667#
X0 a_120_n575# a_n120_n667# a_n208_n575# a_n346_n761# nfet_03v3 ad=2.53p pd=12.38u as=2.53p ps=12.38u w=5.75u l=1.2u
C0 a_120_n575# a_n208_n575# 0.17724f
C1 a_120_n575# a_n120_n667# 0.13575f
C2 a_n208_n575# a_n120_n667# 0.13575f
C3 a_120_n575# a_n346_n761# 1.11702f
C4 a_n208_n575# a_n346_n761# 1.11702f
.ends

.subckt BIAS_3v3 VDDH VbiasP VbiasN VSS
XM1 VbiasN VbiasN VbiasN VSS VbiasN VbiasN VbiasN VbiasN VSS VSS VSS VSS VbiasN VbiasN
+ VbiasN VSS VbiasN VbiasN nfet_03v3_V2UEBS
XM2 VbiasN m1_7390_750# VbiasN VSS m1_7390_750# VbiasN m1_7390_750# VbiasN VSS VSS
+ VSS VSS m1_7390_750# VbiasN VbiasN VSS VbiasN VbiasN nfet_03v3_V2UEBS
XM3 m1_7390_750# m1_7390_750# VbiasP m1_7390_750# VbiasP VbiasP VSS VbiasP VbiasP
+ VbiasP VbiasP VbiasP m1_7390_750# VbiasP VbiasP VbiasP VbiasP m1_7390_750# nfet_03v3_KVBDJ8
XM4 VbiasP VbiasP VbiasP VbiasP VbiasP VbiasP VbiasP VDDH VbiasP VbiasP VbiasP VDDH
+ VDDH VbiasP VbiasP VbiasP VbiasP VDDH VDDH VDDH VbiasP VbiasP VbiasP VbiasP VbiasP
+ VbiasP VbiasP VbiasP VbiasP VbiasP VbiasP VbiasP VDDH VbiasP VbiasP VbiasP VDDH
+ VbiasP VbiasP VbiasP VbiasP VbiasP VbiasP VbiasP VbiasP VbiasP VDDH VDDH VbiasP
+ VbiasP VDDH VDDH VbiasP VbiasP VbiasP VbiasP VDDH VbiasP VDDH VDDH VbiasP VDDH VbiasP
+ VDDH VbiasP VDDH VDDH VSS pfet_03v3_E7RYUB
XM5 VSS VSS VSS VSS nfet_03v3_NVCL9G
XM6 VSS VSS VSS VSS nfet_03v3_NVCL9G
XM7 VDDH VDDH VDDH VDDH VDDH VDDH VDDH VSS pfet_03v3_NFMJS6
XM8 VSS VSS VSS VSS nfet_03v3_W7XH28
C0 VbiasP VbiasN 0.32109f
C1 m1_7390_750# VDDH 0.01798f
C2 VbiasN m1_7390_750# 0.69268f
C3 VbiasN VDDH 0
C4 VbiasP m1_7390_750# 1.72245f
C5 VbiasP VDDH 10.11644f
C6 VDDH VSS -0.53266f
C7 VbiasP VSS 1.9335f
C8 m1_7390_750# VSS 1.53538f
C9 VbiasN VSS 5.27703f
.ends
