** sch_path: /foss/designs/fsm_sar_cosim/test_cosim.sch
**.subckt test_cosim
A1 [ CLK RST START CMP ] [ net1_7 net1_6 net1_5 net1_4 net1_3 net1_2 net1_1 net1_0 net2_7 net2_6 net2_5 net2_4 net2_3 net2_2
+ net2_1 net2_0 net3 net4 ] fsm_sar_model
VCLK CLK 0 PULSE(0 3.3 0 1n 1n 49n 100n)
VRST RST 0 PWL(0 3.3 200n 3.3 201n 0)
VSTART START 0 PULSE(0 3.3 320n 1n 1n 150n 10u)
VCMP CMP 0 0
CRESULT7 net1_7 0 1f
CRESULT6 net1_6 0 1f
CRESULT5 net1_5 0 1f
CRESULT4 net1_4 0 1f
CRESULT3 net1_3 0 1f
CRESULT2 net1_2 0 1f
CRESULT1 net1_1 0 1f
CRESULT0 net1_0 0 1f
CDAC7 net2_7 0 1f
CDAC6 net2_6 0 1f
CDAC5 net2_5 0 1f
CDAC4 net2_4 0 1f
CDAC3 net2_3 0 1f
CDAC2 net2_2 0 1f
CDAC1 net2_1 0 1f
CDAC0 net2_0 0 1f
CSAMPLE net3 0 1f
CEOC net4 0 1f
**** begin user architecture code

.control

pre_set auto_bridge_d_in = (
".model auto_adc adc_bridge(
in_low='0.9 * 3.3 / 2' in_high='1.1 * 3.3 / 2'
rise_delay=1e-11 fall_delay=1e-11 )"
"auto_bridge%d [ %s ] [ %s ] auto_adc" )

pre_set auto_bridge_d_out = (
".model auto_dac dac_bridge(
out_low=0 out_high=3.3
t_rise=1e-11 t_fall=1e-11 )"
"auto_bridge%d [ %s ] [ %s ] auto_dac" )

save all
tran 1n 2u
remzerovec
write test_cosim.raw

.endc

**** end user architecture code
**.ends
**** begin user architecture code
.model fsm_sar_model d_cosim simulation="ivlng" sim_args=["/foss/designs/fsm_sar_cosim/fsm_sar"] delay=0
**** end user architecture code
.end
