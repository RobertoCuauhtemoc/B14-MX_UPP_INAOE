* NGSPICE file created from comparator_3v3_VSS.ext - technology: gf180mcuD

.subckt nfet_03v3_YWK8CE a_n1068_n217# a_52_n309# a_396_n309# a_n1206_n403# a_980_n217#
+ a_n980_n309# a_n740_n217# a_292_n217# a_n292_n309# a_n52_n217# a_n396_n217# a_n636_n309#
+ a_636_n217# a_740_n309#
X0 a_n396_n217# a_n636_n309# a_n740_n217# a_n1206_n403# nfet_03v3 ad=0.5642p pd=2.69u as=0.5642p ps=2.69u w=2.17u l=1.2u
X1 a_n740_n217# a_n980_n309# a_n1068_n217# a_n1206_n403# nfet_03v3 ad=0.5642p pd=2.69u as=0.9548p ps=5.22u w=2.17u l=1.2u
X2 a_n52_n217# a_n292_n309# a_n396_n217# a_n1206_n403# nfet_03v3 ad=0.5642p pd=2.69u as=0.5642p ps=2.69u w=2.17u l=1.2u
X3 a_292_n217# a_52_n309# a_n52_n217# a_n1206_n403# nfet_03v3 ad=0.5642p pd=2.69u as=0.5642p ps=2.69u w=2.17u l=1.2u
X4 a_636_n217# a_396_n309# a_292_n217# a_n1206_n403# nfet_03v3 ad=0.5642p pd=2.69u as=0.5642p ps=2.69u w=2.17u l=1.2u
X5 a_980_n217# a_740_n309# a_636_n217# a_n1206_n403# nfet_03v3 ad=0.9548p pd=5.22u as=0.5642p ps=2.69u w=2.17u l=1.2u
C0 a_n292_n309# a_n52_n217# 0.05094f
C1 a_n1068_n217# a_n740_n217# 0.0665f
C2 a_n636_n309# a_n292_n309# 0.05997f
C3 a_n1068_n217# a_n980_n309# 0.05094f
C4 a_n292_n309# a_n396_n217# 0.05094f
C5 a_52_n309# a_n52_n217# 0.05094f
C6 a_52_n309# a_292_n217# 0.05094f
C7 a_52_n309# a_396_n309# 0.05997f
C8 a_740_n309# a_636_n217# 0.05094f
C9 a_n52_n217# a_292_n217# 0.0665f
C10 a_636_n217# a_292_n217# 0.0665f
C11 a_n636_n309# a_n740_n217# 0.05094f
C12 a_n52_n217# a_n396_n217# 0.0665f
C13 a_740_n309# a_980_n217# 0.05094f
C14 a_636_n217# a_980_n217# 0.0665f
C15 a_740_n309# a_396_n309# 0.05997f
C16 a_n740_n217# a_n396_n217# 0.0665f
C17 a_n636_n309# a_n396_n217# 0.05094f
C18 a_n980_n309# a_n740_n217# 0.05094f
C19 a_n636_n309# a_n980_n309# 0.05997f
C20 a_636_n217# a_396_n309# 0.05094f
C21 a_n292_n309# a_52_n309# 0.05997f
C22 a_396_n309# a_292_n217# 0.05094f
C23 a_980_n217# a_n1206_n403# 0.70875f
C24 a_636_n217# a_n1206_n403# 0.89684f
C25 a_292_n217# a_n1206_n403# 0.87043f
C26 a_n52_n217# a_n1206_n403# 0.87013f
C27 a_n396_n217# a_n1206_n403# 0.87043f
C28 a_n740_n217# a_n1206_n403# 0.89684f
C29 a_n1068_n217# a_n1206_n403# 0.70875f
.ends

.subckt pfet_03v3_LN29N7 a_1428_n992# w_n1918_n1110# a_n980_n992# a_n1324_n992# a_n292_n992#
+ a_980_n900# a_n740_n900# a_n1668_n992# a_n1084_n900# a_292_n900# a_n636_n992# a_n52_n900#
+ a_740_n992# a_1324_n900# a_n1428_n900# a_n396_n900# a_52_n992# a_636_n900# a_1084_n992#
+ a_1668_n900# a_n1756_n900# a_396_n992# VSUBS
X0 a_n1084_n900# a_n1324_n992# a_n1428_n900# w_n1918_n1110# pfet_03v3 ad=2.34p pd=9.52u as=2.34p ps=9.52u w=9u l=1.2u
X1 a_n52_n900# a_n292_n992# a_n396_n900# w_n1918_n1110# pfet_03v3 ad=2.34p pd=9.52u as=2.34p ps=9.52u w=9u l=1.2u
X2 a_n1428_n900# a_n1668_n992# a_n1756_n900# w_n1918_n1110# pfet_03v3 ad=2.34p pd=9.52u as=3.96p ps=18.88u w=9u l=1.2u
X3 a_292_n900# a_52_n992# a_n52_n900# w_n1918_n1110# pfet_03v3 ad=2.34p pd=9.52u as=2.34p ps=9.52u w=9u l=1.2u
X4 a_1668_n900# a_1428_n992# a_1324_n900# w_n1918_n1110# pfet_03v3 ad=3.96p pd=18.88u as=2.34p ps=9.52u w=9u l=1.2u
X5 a_636_n900# a_396_n992# a_292_n900# w_n1918_n1110# pfet_03v3 ad=2.34p pd=9.52u as=2.34p ps=9.52u w=9u l=1.2u
X6 a_980_n900# a_740_n992# a_636_n900# w_n1918_n1110# pfet_03v3 ad=2.34p pd=9.52u as=2.34p ps=9.52u w=9u l=1.2u
X7 a_1324_n900# a_1084_n992# a_980_n900# w_n1918_n1110# pfet_03v3 ad=2.34p pd=9.52u as=2.34p ps=9.52u w=9u l=1.2u
X8 a_n396_n900# a_n636_n992# a_n740_n900# w_n1918_n1110# pfet_03v3 ad=2.34p pd=9.52u as=2.34p ps=9.52u w=9u l=1.2u
X9 a_n740_n900# a_n980_n992# a_n1084_n900# w_n1918_n1110# pfet_03v3 ad=2.34p pd=9.52u as=2.34p ps=9.52u w=9u l=1.2u
C0 a_396_n992# a_740_n992# 0.05997f
C1 a_52_n992# a_396_n992# 0.05997f
C2 a_396_n992# a_292_n900# 0.21274f
C3 a_396_n992# w_n1918_n1110# 0.84992f
C4 a_396_n992# a_636_n900# 0.21274f
C5 a_1084_n992# a_740_n992# 0.05997f
C6 a_740_n992# w_n1918_n1110# 0.85023f
C7 a_980_n900# a_740_n992# 0.21274f
C8 a_740_n992# a_636_n900# 0.21274f
C9 a_n1084_n900# a_n1324_n992# 0.21274f
C10 a_n1324_n992# w_n1918_n1110# 0.85112f
C11 a_n1324_n992# a_n980_n992# 0.05997f
C12 a_52_n992# a_292_n900# 0.21274f
C13 a_52_n992# w_n1918_n1110# 0.84961f
C14 a_n1756_n900# w_n1918_n1110# 1.17199f
C15 a_1668_n900# w_n1918_n1110# 1.17199f
C16 a_n1324_n992# a_n1428_n900# 0.21274f
C17 a_n1084_n900# w_n1918_n1110# 0.37124f
C18 a_n1084_n900# a_n980_n992# 0.21274f
C19 a_n636_n992# w_n1918_n1110# 0.84992f
C20 a_n396_n900# a_n636_n992# 0.21274f
C21 a_292_n900# w_n1918_n1110# 0.37123f
C22 a_n636_n992# a_n980_n992# 0.05997f
C23 a_n1756_n900# a_n1428_n900# 0.27776f
C24 a_1084_n992# w_n1918_n1110# 0.85112f
C25 a_n396_n900# w_n1918_n1110# 0.37123f
C26 a_n1324_n992# a_n1668_n992# 0.05997f
C27 a_1084_n992# a_980_n900# 0.21274f
C28 a_n980_n992# w_n1918_n1110# 0.85023f
C29 a_52_n992# a_n292_n992# 0.05997f
C30 a_n1084_n900# a_n1428_n900# 0.27776f
C31 a_980_n900# w_n1918_n1110# 0.37124f
C32 a_n1084_n900# a_n740_n900# 0.27776f
C33 a_1428_n992# a_1668_n900# 0.21274f
C34 a_52_n992# a_n52_n900# 0.21274f
C35 a_n1428_n900# w_n1918_n1110# 0.37128f
C36 a_n1756_n900# a_n1668_n992# 0.21274f
C37 a_n740_n900# a_n636_n992# 0.21274f
C38 a_n636_n992# a_n292_n992# 0.05997f
C39 a_1324_n900# a_1668_n900# 0.27776f
C40 a_292_n900# a_636_n900# 0.27776f
C41 a_n740_n900# w_n1918_n1110# 0.37123f
C42 a_n740_n900# a_n396_n900# 0.27776f
C43 a_n292_n992# w_n1918_n1110# 0.84961f
C44 a_n740_n900# a_n980_n992# 0.21274f
C45 a_n396_n900# a_n292_n992# 0.21274f
C46 a_636_n900# w_n1918_n1110# 0.37123f
C47 a_1084_n992# a_1428_n992# 0.05997f
C48 a_n52_n900# a_292_n900# 0.27776f
C49 a_1428_n992# w_n1918_n1110# 0.89309f
C50 a_980_n900# a_636_n900# 0.27776f
C51 w_n1918_n1110# a_n1668_n992# 0.89309f
C52 a_n52_n900# w_n1918_n1110# 0.37122f
C53 a_1084_n992# a_1324_n900# 0.21274f
C54 a_n396_n900# a_n52_n900# 0.27776f
C55 a_1324_n900# w_n1918_n1110# 0.37128f
C56 a_980_n900# a_1324_n900# 0.27776f
C57 a_n1428_n900# a_n1668_n992# 0.21274f
C58 a_n52_n900# a_n292_n992# 0.21274f
C59 a_1428_n992# a_1324_n900# 0.21274f
C60 a_1668_n900# VSUBS 0.0367f
C61 a_1324_n900# VSUBS 0.06825f
C62 a_980_n900# VSUBS 0.0631f
C63 a_636_n900# VSUBS 0.0631f
C64 a_292_n900# VSUBS 0.0631f
C65 a_n52_n900# VSUBS 0.0631f
C66 a_n396_n900# VSUBS 0.0631f
C67 a_n740_n900# VSUBS 0.0631f
C68 a_n1084_n900# VSUBS 0.0631f
C69 a_n1428_n900# VSUBS 0.06825f
C70 a_n1756_n900# VSUBS 0.0367f
C71 w_n1918_n1110# VSUBS 27.4178f
.ends

.subckt pfet_03v3_UB86XQ a_n2700_n1120# a_2356_n1028# a_n2460_1260# a_n1324_24# a_740_24#
+ a_n2356_n1120# a_n1428_n2172# a_n1668_1168# a_2460_n1120# a_n2012_n2264# a_2460_24#
+ a_2116_n2264# a_1668_n2172# a_n1084_n2172# a_2012_116# a_980_n2172# a_n740_n2172#
+ a_n396_n2172# a_n2700_24# a_n636_1168# a_n980_24# a_52_n2264# a_740_1168# a_52_24#
+ a_n2788_n1028# a_2700_116# a_2700_1260# a_n2460_n1028# a_396_24# a_2116_24# a_n2700_n2264#
+ a_2116_1168# a_1772_24# a_n2356_n2264# a_n1772_n2172# a_1772_1168# a_2012_1260#
+ a_n52_n1028# a_2460_n2264# a_2012_n2172# a_636_n1028# a_52_1168# a_n2116_1260# a_1324_n1028#
+ a_n636_24# w_n2950_n2382# a_n1324_n1120# a_n1772_1260# a_1428_n1120# a_292_n1028#
+ a_n2356_24# a_1084_1168# a_740_n1120# a_n636_n1120# a_396_n1120# a_n2700_1168# a_980_1260#
+ a_1084_n1120# a_n396_116# a_n740_1260# a_n292_n1120# a_n1084_1260# a_1428_24# a_396_1168#
+ a_n2116_n2172# a_2356_1260# a_n2012_1168# a_n1428_n1028# a_2700_n2172# a_292_1260#
+ a_2356_n2172# a_n1084_116# a_1668_n1028# a_292_116# a_n1084_n1028# a_n1668_n1120#
+ a_980_n1028# a_n52_1260# a_n1668_24# a_n740_n1028# a_n396_n1028# a_1772_n1120# a_n1324_n2264#
+ a_1428_1168# a_n1772_116# a_1428_n2264# a_740_n2264# a_n980_n1120# a_n636_n2264#
+ a_396_n2264# a_1324_1260# a_980_116# a_1084_n2264# a_n740_116# a_n1428_1260# a_n2788_1260#
+ a_n2356_1168# a_n2788_n2172# a_n292_n2264# a_n52_116# a_n2460_n2172# a_n396_1260#
+ a_636_1260# a_n1772_n1028# a_n2460_116# a_n2788_116# a_2012_n1028# a_1668_116# a_n980_1168#
+ a_n2012_n1120# a_n2012_24# a_2116_n1120# a_n1668_n2264# a_n52_n2172# a_n292_24#
+ a_n1428_116# a_636_n2172# a_1668_1260# a_n1324_1168# a_636_116# a_1772_n2264# a_1324_n2172#
+ a_292_n2172# a_n292_1168# a_n980_n2264# a_52_n1120# a_2460_1168# a_2356_116# a_1084_24#
+ a_1324_116# a_n2116_n1028# a_n2116_116# a_2700_n1028# VSUBS
X0 a_n1772_116# a_n2012_24# a_n2116_116# w_n2950_n2382# pfet_03v3 ad=1.1856p pd=5.08u as=1.1856p ps=5.08u w=4.56u l=1.2u
X1 a_n1772_1260# a_n2012_1168# a_n2116_1260# w_n2950_n2382# pfet_03v3 ad=1.1856p pd=5.08u as=1.1856p ps=5.08u w=4.56u l=1.2u
X2 a_636_n2172# a_396_n2264# a_292_n2172# w_n2950_n2382# pfet_03v3 ad=1.1856p pd=5.08u as=1.1856p ps=5.08u w=4.56u l=1.2u
X3 a_1324_n2172# a_1084_n2264# a_980_n2172# w_n2950_n2382# pfet_03v3 ad=1.1856p pd=5.08u as=1.1856p ps=5.08u w=4.56u l=1.2u
X4 a_2356_n2172# a_2116_n2264# a_2012_n2172# w_n2950_n2382# pfet_03v3 ad=1.1856p pd=5.08u as=1.1856p ps=5.08u w=4.56u l=1.2u
X5 a_1668_1260# a_1428_1168# a_1324_1260# w_n2950_n2382# pfet_03v3 ad=1.1856p pd=5.08u as=1.1856p ps=5.08u w=4.56u l=1.2u
X6 a_1324_116# a_1084_24# a_980_116# w_n2950_n2382# pfet_03v3 ad=1.1856p pd=5.08u as=1.1856p ps=5.08u w=4.56u l=1.2u
X7 a_n740_n2172# a_n980_n2264# a_n1084_n2172# w_n2950_n2382# pfet_03v3 ad=1.1856p pd=5.08u as=1.1856p ps=5.08u w=4.56u l=1.2u
X8 a_n2116_1260# a_n2356_1168# a_n2460_1260# w_n2950_n2382# pfet_03v3 ad=1.1856p pd=5.08u as=1.1856p ps=5.08u w=4.56u l=1.2u
X9 a_n2460_1260# a_n2700_1168# a_n2788_1260# w_n2950_n2382# pfet_03v3 ad=1.1856p pd=5.08u as=2.0064p ps=10u w=4.56u l=1.2u
X10 a_1668_116# a_1428_24# a_1324_116# w_n2950_n2382# pfet_03v3 ad=1.1856p pd=5.08u as=1.1856p ps=5.08u w=4.56u l=1.2u
X11 a_n1428_n1028# a_n1668_n1120# a_n1772_n1028# w_n2950_n2382# pfet_03v3 ad=1.1856p pd=5.08u as=1.1856p ps=5.08u w=4.56u l=1.2u
X12 a_2012_n1028# a_1772_n1120# a_1668_n1028# w_n2950_n2382# pfet_03v3 ad=1.1856p pd=5.08u as=1.1856p ps=5.08u w=4.56u l=1.2u
X13 a_636_1260# a_396_1168# a_292_1260# w_n2950_n2382# pfet_03v3 ad=1.1856p pd=5.08u as=1.1856p ps=5.08u w=4.56u l=1.2u
X14 a_636_116# a_396_24# a_292_116# w_n2950_n2382# pfet_03v3 ad=1.1856p pd=5.08u as=1.1856p ps=5.08u w=4.56u l=1.2u
X15 a_980_116# a_740_24# a_636_116# w_n2950_n2382# pfet_03v3 ad=1.1856p pd=5.08u as=1.1856p ps=5.08u w=4.56u l=1.2u
X16 a_n1428_116# a_n1668_24# a_n1772_116# w_n2950_n2382# pfet_03v3 ad=1.1856p pd=5.08u as=1.1856p ps=5.08u w=4.56u l=1.2u
X17 a_980_1260# a_740_1168# a_636_1260# w_n2950_n2382# pfet_03v3 ad=1.1856p pd=5.08u as=1.1856p ps=5.08u w=4.56u l=1.2u
X18 a_n2116_n1028# a_n2356_n1120# a_n2460_n1028# w_n2950_n2382# pfet_03v3 ad=1.1856p pd=5.08u as=1.1856p ps=5.08u w=4.56u l=1.2u
X19 a_2700_n1028# a_2460_n1120# a_2356_n1028# w_n2950_n2382# pfet_03v3 ad=2.0064p pd=10u as=1.1856p ps=5.08u w=4.56u l=1.2u
X20 a_n1428_n2172# a_n1668_n2264# a_n1772_n2172# w_n2950_n2382# pfet_03v3 ad=1.1856p pd=5.08u as=1.1856p ps=5.08u w=4.56u l=1.2u
X21 a_2012_n2172# a_1772_n2264# a_1668_n2172# w_n2950_n2382# pfet_03v3 ad=1.1856p pd=5.08u as=1.1856p ps=5.08u w=4.56u l=1.2u
X22 a_1324_1260# a_1084_1168# a_980_1260# w_n2950_n2382# pfet_03v3 ad=1.1856p pd=5.08u as=1.1856p ps=5.08u w=4.56u l=1.2u
X23 a_n2116_n2172# a_n2356_n2264# a_n2460_n2172# w_n2950_n2382# pfet_03v3 ad=1.1856p pd=5.08u as=1.1856p ps=5.08u w=4.56u l=1.2u
X24 a_2700_n2172# a_2460_n2264# a_2356_n2172# w_n2950_n2382# pfet_03v3 ad=2.0064p pd=10u as=1.1856p ps=5.08u w=4.56u l=1.2u
X25 a_2012_1260# a_1772_1168# a_1668_1260# w_n2950_n2382# pfet_03v3 ad=1.1856p pd=5.08u as=1.1856p ps=5.08u w=4.56u l=1.2u
X26 a_n396_1260# a_n636_1168# a_n740_1260# w_n2950_n2382# pfet_03v3 ad=1.1856p pd=5.08u as=1.1856p ps=5.08u w=4.56u l=1.2u
X27 a_n396_n1028# a_n636_n1120# a_n740_n1028# w_n2950_n2382# pfet_03v3 ad=1.1856p pd=5.08u as=1.1856p ps=5.08u w=4.56u l=1.2u
X28 a_n1084_116# a_n1324_24# a_n1428_116# w_n2950_n2382# pfet_03v3 ad=1.1856p pd=5.08u as=1.1856p ps=5.08u w=4.56u l=1.2u
X29 a_2700_116# a_2460_24# a_2356_116# w_n2950_n2382# pfet_03v3 ad=2.0064p pd=10u as=1.1856p ps=5.08u w=4.56u l=1.2u
X30 a_n740_1260# a_n980_1168# a_n1084_1260# w_n2950_n2382# pfet_03v3 ad=1.1856p pd=5.08u as=1.1856p ps=5.08u w=4.56u l=1.2u
X31 a_2356_1260# a_2116_1168# a_2012_1260# w_n2950_n2382# pfet_03v3 ad=1.1856p pd=5.08u as=1.1856p ps=5.08u w=4.56u l=1.2u
X32 a_n740_116# a_n980_24# a_n1084_116# w_n2950_n2382# pfet_03v3 ad=1.1856p pd=5.08u as=1.1856p ps=5.08u w=4.56u l=1.2u
X33 a_n396_n2172# a_n636_n2264# a_n740_n2172# w_n2950_n2382# pfet_03v3 ad=1.1856p pd=5.08u as=1.1856p ps=5.08u w=4.56u l=1.2u
X34 a_n52_n1028# a_n292_n1120# a_n396_n1028# w_n2950_n2382# pfet_03v3 ad=1.1856p pd=5.08u as=1.1856p ps=5.08u w=4.56u l=1.2u
X35 a_n2460_116# a_n2700_24# a_n2788_116# w_n2950_n2382# pfet_03v3 ad=1.1856p pd=5.08u as=2.0064p ps=10u w=4.56u l=1.2u
X36 a_n1084_1260# a_n1324_1168# a_n1428_1260# w_n2950_n2382# pfet_03v3 ad=1.1856p pd=5.08u as=1.1856p ps=5.08u w=4.56u l=1.2u
X37 a_n1084_n1028# a_n1324_n1120# a_n1428_n1028# w_n2950_n2382# pfet_03v3 ad=1.1856p pd=5.08u as=1.1856p ps=5.08u w=4.56u l=1.2u
X38 a_980_n1028# a_740_n1120# a_636_n1028# w_n2950_n2382# pfet_03v3 ad=1.1856p pd=5.08u as=1.1856p ps=5.08u w=4.56u l=1.2u
X39 a_n52_n2172# a_n292_n2264# a_n396_n2172# w_n2950_n2382# pfet_03v3 ad=1.1856p pd=5.08u as=1.1856p ps=5.08u w=4.56u l=1.2u
X40 a_n1428_1260# a_n1668_1168# a_n1772_1260# w_n2950_n2382# pfet_03v3 ad=1.1856p pd=5.08u as=1.1856p ps=5.08u w=4.56u l=1.2u
X41 a_n52_1260# a_n292_1168# a_n396_1260# w_n2950_n2382# pfet_03v3 ad=1.1856p pd=5.08u as=1.1856p ps=5.08u w=4.56u l=1.2u
X42 a_n52_116# a_n292_24# a_n396_116# w_n2950_n2382# pfet_03v3 ad=1.1856p pd=5.08u as=1.1856p ps=5.08u w=4.56u l=1.2u
X43 a_980_n2172# a_740_n2264# a_636_n2172# w_n2950_n2382# pfet_03v3 ad=1.1856p pd=5.08u as=1.1856p ps=5.08u w=4.56u l=1.2u
X44 a_2356_116# a_2116_24# a_2012_116# w_n2950_n2382# pfet_03v3 ad=1.1856p pd=5.08u as=1.1856p ps=5.08u w=4.56u l=1.2u
X45 a_n1772_n1028# a_n2012_n1120# a_n2116_n1028# w_n2950_n2382# pfet_03v3 ad=1.1856p pd=5.08u as=1.1856p ps=5.08u w=4.56u l=1.2u
X46 a_n1084_n2172# a_n1324_n2264# a_n1428_n2172# w_n2950_n2382# pfet_03v3 ad=1.1856p pd=5.08u as=1.1856p ps=5.08u w=4.56u l=1.2u
X47 a_n396_116# a_n636_24# a_n740_116# w_n2950_n2382# pfet_03v3 ad=1.1856p pd=5.08u as=1.1856p ps=5.08u w=4.56u l=1.2u
X48 a_292_116# a_52_24# a_n52_116# w_n2950_n2382# pfet_03v3 ad=1.1856p pd=5.08u as=1.1856p ps=5.08u w=4.56u l=1.2u
X49 a_292_n1028# a_52_n1120# a_n52_n1028# w_n2950_n2382# pfet_03v3 ad=1.1856p pd=5.08u as=1.1856p ps=5.08u w=4.56u l=1.2u
X50 a_292_1260# a_52_1168# a_n52_1260# w_n2950_n2382# pfet_03v3 ad=1.1856p pd=5.08u as=1.1856p ps=5.08u w=4.56u l=1.2u
X51 a_n2116_116# a_n2356_24# a_n2460_116# w_n2950_n2382# pfet_03v3 ad=1.1856p pd=5.08u as=1.1856p ps=5.08u w=4.56u l=1.2u
X52 a_n1772_n2172# a_n2012_n2264# a_n2116_n2172# w_n2950_n2382# pfet_03v3 ad=1.1856p pd=5.08u as=1.1856p ps=5.08u w=4.56u l=1.2u
X53 a_2700_1260# a_2460_1168# a_2356_1260# w_n2950_n2382# pfet_03v3 ad=2.0064p pd=10u as=1.1856p ps=5.08u w=4.56u l=1.2u
X54 a_n2460_n1028# a_n2700_n1120# a_n2788_n1028# w_n2950_n2382# pfet_03v3 ad=1.1856p pd=5.08u as=2.0064p ps=10u w=4.56u l=1.2u
X55 a_1668_n1028# a_1428_n1120# a_1324_n1028# w_n2950_n2382# pfet_03v3 ad=1.1856p pd=5.08u as=1.1856p ps=5.08u w=4.56u l=1.2u
X56 a_292_n2172# a_52_n2264# a_n52_n2172# w_n2950_n2382# pfet_03v3 ad=1.1856p pd=5.08u as=1.1856p ps=5.08u w=4.56u l=1.2u
X57 a_2012_116# a_1772_24# a_1668_116# w_n2950_n2382# pfet_03v3 ad=1.1856p pd=5.08u as=1.1856p ps=5.08u w=4.56u l=1.2u
X58 a_n2460_n2172# a_n2700_n2264# a_n2788_n2172# w_n2950_n2382# pfet_03v3 ad=1.1856p pd=5.08u as=2.0064p ps=10u w=4.56u l=1.2u
X59 a_636_n1028# a_396_n1120# a_292_n1028# w_n2950_n2382# pfet_03v3 ad=1.1856p pd=5.08u as=1.1856p ps=5.08u w=4.56u l=1.2u
X60 a_2356_n1028# a_2116_n1120# a_2012_n1028# w_n2950_n2382# pfet_03v3 ad=1.1856p pd=5.08u as=1.1856p ps=5.08u w=4.56u l=1.2u
X61 a_1668_n2172# a_1428_n2264# a_1324_n2172# w_n2950_n2382# pfet_03v3 ad=1.1856p pd=5.08u as=1.1856p ps=5.08u w=4.56u l=1.2u
X62 a_n740_n1028# a_n980_n1120# a_n1084_n1028# w_n2950_n2382# pfet_03v3 ad=1.1856p pd=5.08u as=1.1856p ps=5.08u w=4.56u l=1.2u
X63 a_1324_n1028# a_1084_n1120# a_980_n1028# w_n2950_n2382# pfet_03v3 ad=1.1856p pd=5.08u as=1.1856p ps=5.08u w=4.56u l=1.2u
C0 a_n2356_24# a_n2356_n1120# 0.22367f
C1 w_n2950_n2382# a_n2788_116# 0.57484f
C2 a_n1324_n2264# a_n1324_n1120# 0.22367f
C3 a_n740_1260# a_n636_1168# 0.10756f
C4 a_n1668_n2264# a_n1668_n1120# 0.22367f
C5 a_n2788_116# a_n2460_116# 0.14043f
C6 a_n2356_n2264# a_n2356_n1120# 0.22367f
C7 a_2700_116# a_2700_n1028# 0.0083f
C8 a_1324_116# a_1324_n1028# 0.0083f
C9 a_n396_116# a_n396_n1028# 0.0083f
C10 a_n1772_116# a_n1668_24# 0.10756f
C11 a_2700_116# a_2700_1260# 0.0083f
C12 a_n1772_116# w_n2950_n2382# 0.16694f
C13 a_1668_116# w_n2950_n2382# 0.16694f
C14 w_n2950_n2382# a_n1324_n1120# 0.29633f
C15 a_n2700_n1120# w_n2950_n2382# 0.33982f
C16 a_636_1260# a_636_116# 0.0083f
C17 a_n2012_n2264# a_n2012_n1120# 0.22367f
C18 a_2460_24# a_2460_1168# 0.22367f
C19 a_n1668_24# a_n1668_n1120# 0.22367f
C20 a_2012_116# a_2012_n1028# 0.0083f
C21 a_n2116_116# w_n2950_n2382# 0.16695f
C22 a_n396_116# w_n2950_n2382# 0.16693f
C23 a_636_n1028# a_636_116# 0.0083f
C24 a_1324_116# w_n2950_n2382# 0.16693f
C25 w_n2950_n2382# a_n1668_n1120# 0.29665f
C26 a_2700_116# w_n2950_n2382# 0.57484f
C27 w_n2950_n2382# a_n2012_n1120# 0.29695f
C28 a_2460_n1120# a_2460_24# 0.22367f
C29 a_292_n1028# a_292_116# 0.0083f
C30 a_2012_116# a_2012_1260# 0.0083f
C31 a_n1084_116# w_n2950_n2382# 0.16693f
C32 a_n2116_116# a_n2460_116# 0.14043f
C33 a_n52_n1028# a_n52_116# 0.0083f
C34 a_52_n1120# a_396_n1120# 0.05997f
C35 a_740_n1120# a_740_24# 0.22367f
C36 a_n740_1260# a_n980_1168# 0.10756f
C37 a_2356_116# a_2356_n1028# 0.0083f
C38 a_980_n1028# a_980_116# 0.0083f
C39 a_n740_116# w_n2950_n2382# 0.16693f
C40 w_n2950_n2382# a_n2356_n1120# 0.29785f
C41 a_n1428_116# a_n1668_24# 0.10756f
C42 a_n1428_116# w_n2950_n2382# 0.16693f
C43 w_n2950_n2382# a_980_116# 0.16693f
C44 a_n980_1168# a_n980_24# 0.22367f
C45 a_2356_116# w_n2950_n2382# 0.16699f
C46 a_n740_1260# a_n396_1260# 0.14043f
C47 w_n2950_n2382# a_292_116# 0.16693f
C48 a_n52_1260# a_n52_116# 0.0083f
C49 a_52_n1120# a_n52_n1028# 0.10756f
C50 a_n1084_1260# w_n2950_n2382# 0.18803f
C51 a_n2116_116# a_n1772_116# 0.14043f
C52 w_n2950_n2382# a_636_116# 0.16693f
C53 a_2012_116# w_n2950_n2382# 0.16695f
C54 a_1324_116# a_1668_116# 0.14043f
C55 a_52_n1120# a_52_n2264# 0.22367f
C56 a_292_n1028# a_52_n1120# 0.10756f
C57 a_n1668_n1120# a_n1324_n1120# 0.05997f
C58 w_n2950_n2382# a_n52_116# 0.16693f
C59 a_n1324_24# a_n1668_24# 0.05997f
C60 a_n292_n1120# a_n292_n2264# 0.22367f
C61 a_n292_n1120# a_n52_n1028# 0.10756f
C62 a_n1324_24# w_n2950_n2382# 0.29633f
C63 a_1428_24# a_1428_1168# 0.22367f
C64 a_n292_24# a_n292_1168# 0.22367f
C65 w_n2950_n2382# a_2460_24# 0.33982f
C66 a_n1428_116# a_n1772_116# 0.14043f
C67 a_n2012_n1120# a_n1668_n1120# 0.05997f
C68 a_n2700_n1120# a_n2356_n1120# 0.05997f
C69 a_n292_n1120# a_n396_n1028# 0.10756f
C70 a_52_n1120# w_n2950_n2382# 0.29627f
C71 a_52_24# a_52_1168# 0.22367f
C72 a_n740_n1028# a_n636_n1120# 0.10756f
C73 w_n2950_n2382# a_1084_24# 0.29633f
C74 a_n740_116# a_n396_116# 0.14043f
C75 a_1772_24# a_1772_1168# 0.22367f
C76 w_n2950_n2382# a_2116_24# 0.29785f
C77 a_740_1168# a_740_24# 0.22367f
C78 a_n1084_116# a_n740_116# 0.14043f
C79 a_1772_24# w_n2950_n2382# 0.29695f
C80 a_n636_24# w_n2950_n2382# 0.29627f
C81 a_n2356_n1120# a_n2012_n1120# 0.05997f
C82 a_1324_116# a_980_116# 0.14043f
C83 a_396_1168# a_396_24# 0.22367f
C84 a_1668_116# a_2012_116# 0.14043f
C85 a_2700_116# a_2356_116# 0.14043f
C86 a_n292_n1120# w_n2950_n2382# 0.29627f
C87 w_n2950_n2382# a_740_24# 0.29627f
C88 a_n1428_116# a_n1084_116# 0.14043f
C89 a_n740_n1028# a_n980_n1120# 0.10756f
C90 a_52_24# w_n2950_n2382# 0.29627f
C91 a_n1324_24# a_n1324_n1120# 0.22367f
C92 a_1428_24# w_n2950_n2382# 0.29665f
C93 a_396_24# a_396_n1120# 0.22367f
C94 a_n396_116# a_n52_116# 0.14043f
C95 a_n1084_1260# a_n1084_116# 0.0083f
C96 a_n1084_n1028# a_n980_n1120# 0.10756f
C97 a_n740_1260# w_n2950_n2382# 0.18803f
C98 a_n1084_116# a_n1324_24# 0.10756f
C99 a_n2460_1260# a_n2700_1168# 0.10756f
C100 a_n980_24# w_n2950_n2382# 0.29627f
C101 a_n636_n1120# a_n396_n1028# 0.10756f
C102 a_n636_n2264# a_n636_n1120# 0.22367f
C103 a_n980_n2264# a_n980_n1120# 0.22367f
C104 a_636_116# a_980_116# 0.14043f
C105 a_2700_116# a_2460_24# 0.10756f
C106 a_1772_24# a_1668_116# 0.10756f
C107 a_2012_116# a_2356_116# 0.14043f
C108 a_636_116# a_292_116# 0.14043f
C109 a_1324_116# a_1084_24# 0.10756f
C110 a_n1428_116# a_n1324_24# 0.10756f
C111 a_n52_116# a_292_116# 0.14043f
C112 a_n2116_1260# a_n1772_1260# 0.14043f
C113 a_1428_24# a_1668_116# 0.10756f
C114 a_n636_24# a_n396_116# 0.10756f
C115 w_n2950_n2382# a_n636_n1120# 0.29627f
C116 a_2356_116# a_2460_24# 0.10756f
C117 a_n292_24# w_n2950_n2382# 0.29627f
C118 a_980_116# a_1084_24# 0.10756f
C119 a_1428_24# a_1324_116# 0.10756f
C120 a_n636_24# a_n740_116# 0.10756f
C121 w_n2950_n2382# a_n980_n1120# 0.29627f
C122 a_396_24# w_n2950_n2382# 0.29627f
C123 a_2356_116# a_2116_24# 0.10756f
C124 a_980_116# a_740_24# 0.10756f
C125 a_2012_116# a_2116_24# 0.10756f
C126 a_52_24# a_292_116# 0.10756f
C127 a_1772_24# a_2012_116# 0.10756f
C128 a_n740_1260# a_n740_116# 0.0083f
C129 a_n1084_116# a_n980_24# 0.10756f
C130 a_636_116# a_740_24# 0.10756f
C131 a_n2460_1260# a_n2356_1168# 0.10756f
C132 a_n980_24# a_n740_116# 0.10756f
C133 a_52_24# a_n52_116# 0.10756f
C134 a_2116_24# a_2460_24# 0.05997f
C135 w_n2950_n2382# a_n2460_1260# 0.18809f
C136 a_n1324_n1120# a_n980_n1120# 0.05997f
C137 a_n1084_1260# a_n740_1260# 0.14043f
C138 a_n292_24# a_n396_116# 0.10756f
C139 a_n2460_116# a_n2460_1260# 0.0083f
C140 a_n292_n1120# a_52_n1120# 0.05997f
C141 a_740_24# a_1084_24# 0.05997f
C142 a_1772_n1120# a_2116_n1120# 0.05997f
C143 a_1772_24# a_2116_24# 0.05997f
C144 a_52_24# a_52_n1120# 0.22367f
C145 a_1428_24# a_1084_24# 0.05997f
C146 a_n1324_24# a_n980_24# 0.05997f
C147 a_1428_24# a_1772_24# 0.05997f
C148 a_1772_n1120# a_1428_n1120# 0.05997f
C149 a_396_24# a_292_116# 0.10756f
C150 a_n292_24# a_n52_116# 0.10756f
C151 a_n636_24# a_n980_24# 0.05997f
C152 a_396_24# a_636_116# 0.10756f
C153 a_1084_n1120# a_1428_n1120# 0.05997f
C154 a_n636_24# a_n636_n1120# 0.22367f
C155 a_n292_n1120# a_n636_n1120# 0.05997f
C156 a_n636_24# a_n292_24# 0.05997f
C157 a_n1428_1260# a_n1772_1260# 0.14043f
C158 a_2116_1168# a_2356_1260# 0.10756f
C159 a_n292_24# a_n292_n1120# 0.22367f
C160 a_n2788_1260# a_n2700_1168# 0.10756f
C161 a_n292_24# a_52_24# 0.05997f
C162 a_396_24# a_740_24# 0.05997f
C163 a_2116_1168# a_2460_1168# 0.05997f
C164 a_1772_n1120# a_1772_n2264# 0.22367f
C165 a_52_24# a_396_24# 0.05997f
C166 a_2116_n1120# a_2116_n2264# 0.22367f
C167 a_n980_24# a_n980_n1120# 0.22367f
C168 a_1428_n2264# a_1428_n1120# 0.22367f
C169 a_n2012_1168# a_n1772_1260# 0.10756f
C170 a_2012_1260# a_2116_1168# 0.10756f
C171 a_n980_n1120# a_n636_n1120# 0.05997f
C172 a_n2116_1260# a_n2012_1168# 0.10756f
C173 a_2116_1168# a_1772_1168# 0.05997f
C174 w_n2950_n2382# a_n2788_1260# 0.59408f
C175 w_n2950_n2382# a_2116_1168# 0.57107f
C176 a_2460_n1120# a_2116_n1120# 0.05997f
C177 a_n52_n2172# a_292_n2172# 0.14043f
C178 a_1772_n2264# a_1668_n2172# 0.10756f
C179 a_2356_n2172# a_2700_n2172# 0.14043f
C180 a_n2788_116# a_n2788_1260# 0.0083f
C181 a_2460_n2264# a_2356_n2172# 0.10756f
C182 a_1428_n2264# a_1772_n2264# 0.05997f
C183 a_1772_n2264# a_2012_n2172# 0.10756f
C184 a_2012_n2172# a_2356_n2172# 0.14043f
C185 a_n52_n2172# a_n396_n2172# 0.14043f
C186 a_2012_n2172# a_1668_n2172# 0.14043f
C187 a_292_n2172# a_636_n2172# 0.14043f
C188 a_1428_n2264# a_1668_n2172# 0.10756f
C189 a_n2116_1260# a_n2356_1168# 0.10756f
C190 a_2012_n1028# a_2116_n1120# 0.10756f
C191 w_n2950_n2382# a_n1772_1260# 0.18805f
C192 a_1324_n2172# a_1668_n2172# 0.14043f
C193 a_n1668_1168# a_n1772_1260# 0.10756f
C194 a_980_n2172# a_1324_n2172# 0.14043f
C195 a_2460_n2264# a_2700_n2172# 0.10756f
C196 a_740_n1120# a_1084_n1120# 0.05997f
C197 a_2116_n2264# a_1772_n2264# 0.05997f
C198 a_2116_n2264# a_2356_n2172# 0.10756f
C199 a_636_n2172# a_980_n2172# 0.14043f
C200 a_1428_n2264# a_1324_n2172# 0.10756f
C201 a_n2116_1260# w_n2950_n2382# 0.18806f
C202 a_n740_n2172# a_n396_n2172# 0.14043f
C203 a_2012_n1028# a_1772_n1120# 0.10756f
C204 a_n740_n2172# a_n1084_n2172# 0.14043f
C205 a_n1772_n2172# a_n1428_n2172# 0.14043f
C206 a_n1428_n2172# a_n1084_n2172# 0.14043f
C207 a_n2116_n2172# a_n1772_n2172# 0.14043f
C208 a_n2460_n2172# a_n2116_n2172# 0.14043f
C209 a_n2788_n2172# a_n2460_n2172# 0.14043f
C210 a_2116_n2264# a_2460_n2264# 0.05997f
C211 a_2116_n2264# a_2012_n2172# 0.10756f
C212 a_2116_n1120# a_2356_n1028# 0.10756f
C213 a_1668_n1028# a_1772_n1120# 0.10756f
C214 a_n1772_116# a_n1772_1260# 0.0083f
C215 a_2116_n1120# w_n2950_n2382# 0.29785f
C216 a_1084_n2264# a_1084_n1120# 0.22367f
C217 a_1668_n1028# a_1428_n1120# 0.10756f
C218 a_1324_n1028# a_1428_n1120# 0.10756f
C219 a_1772_n1120# w_n2950_n2382# 0.29695f
C220 a_n980_1168# a_n636_1168# 0.05997f
C221 a_1084_1168# a_980_1260# 0.10756f
C222 a_1324_n1028# a_1084_n1120# 0.10756f
C223 a_n292_1168# a_n636_1168# 0.05997f
C224 a_n1428_1260# a_n1324_1168# 0.10756f
C225 a_n2116_n2172# a_n2116_n1028# 0.0083f
C226 a_n2460_n2172# a_n2460_n1028# 0.0083f
C227 a_n636_1168# a_n396_1260# 0.10756f
C228 a_n2116_1260# a_n2116_116# 0.0083f
C229 w_n2950_n2382# a_1428_n1120# 0.29665f
C230 a_980_n1028# a_1084_n1120# 0.10756f
C231 a_n2700_24# a_n2700_1168# 0.22367f
C232 a_n980_1168# a_n1324_1168# 0.05997f
C233 a_292_n2172# a_396_n2264# 0.10756f
C234 w_n2950_n2382# a_1084_n1120# 0.29633f
C235 a_n740_n1028# a_n740_n2172# 0.0083f
C236 a_n2788_n1028# a_n2788_n2172# 0.0083f
C237 a_396_1168# a_292_1260# 0.10756f
C238 a_n1084_n1028# a_n1084_n2172# 0.0083f
C239 a_2460_n1120# a_2460_n2264# 0.22367f
C240 a_n1772_n2172# a_n1772_n1028# 0.0083f
C241 a_n1428_n1028# a_n1428_n2172# 0.0083f
C242 a_1084_n2264# a_980_n2172# 0.10756f
C243 a_292_n2172# a_52_n2264# 0.10756f
C244 a_n2460_n2172# a_n2356_n2264# 0.10756f
C245 a_292_n2172# a_292_n1028# 0.0083f
C246 a_1084_n2264# a_1428_n2264# 0.05997f
C247 a_n396_n2172# a_n292_n2264# 0.10756f
C248 a_n52_n2172# a_n292_n2264# 0.10756f
C249 a_n52_n2172# a_n52_n1028# 0.0083f
C250 a_n2700_24# a_n2356_24# 0.05997f
C251 a_2012_n1028# a_2012_n2172# 0.0083f
C252 a_1084_n2264# a_1324_n2172# 0.10756f
C253 a_2116_1168# a_2116_24# 0.22367f
C254 a_n980_n2264# a_n1084_n2172# 0.10756f
C255 a_1668_n1028# a_1668_n2172# 0.0083f
C256 a_740_n2264# a_980_n2172# 0.10756f
C257 a_n2460_n1028# a_n2116_n1028# 0.14043f
C258 a_n1668_n2264# a_n1772_n2172# 0.10756f
C259 a_n2116_n2172# a_n2356_n2264# 0.10756f
C260 a_292_1260# a_636_1260# 0.14043f
C261 a_396_n2264# a_636_n2172# 0.10756f
C262 a_n292_1168# a_n396_1260# 0.10756f
C263 a_n52_n2172# a_52_n2264# 0.10756f
C264 a_636_n1028# a_636_n2172# 0.0083f
C265 a_n2460_n2172# a_n2700_n2264# 0.10756f
C266 a_2700_n1028# a_2700_n2172# 0.0083f
C267 a_636_1260# a_980_1260# 0.14043f
C268 a_2356_n1028# a_2356_n2172# 0.0083f
C269 a_n980_n2264# a_n740_n2172# 0.10756f
C270 a_n396_n2172# a_n396_n1028# 0.0083f
C271 a_n396_n2172# a_n636_n2264# 0.10756f
C272 a_980_1260# a_1324_1260# 0.14043f
C273 a_n1324_n2264# a_n1084_n2172# 0.10756f
C274 a_2356_1260# a_2460_1168# 0.10756f
C275 a_292_n2172# w_n2950_n2382# 0.18803f
C276 a_1324_n1028# a_1324_n2172# 0.0083f
C277 a_1084_1168# a_1324_1260# 0.10756f
C278 a_740_n2264# a_636_n2172# 0.10756f
C279 a_n1668_n2264# a_n1428_n2172# 0.10756f
C280 a_n2012_n2264# a_n1772_n2172# 0.10756f
C281 w_n2950_n2382# a_1772_n2264# 0.57017f
C282 w_n2950_n2382# a_2356_n2172# 0.18809f
C283 a_n2788_n1028# a_n2460_n1028# 0.14043f
C284 a_980_n1028# a_980_n2172# 0.0083f
C285 a_n2788_n2172# a_n2700_n2264# 0.10756f
C286 a_1084_1168# a_1428_1168# 0.05997f
C287 a_1668_1260# a_1324_1260# 0.14043f
C288 w_n2950_n2382# a_1668_n2172# 0.18805f
C289 a_n740_n2172# a_n636_n2264# 0.10756f
C290 a_1668_1260# a_1428_1168# 0.10756f
C291 a_n1324_n2264# a_n1428_n2172# 0.10756f
C292 w_n2950_n2382# a_980_n2172# 0.18803f
C293 a_n2116_n1028# a_n1772_n1028# 0.14043f
C294 a_n396_n2172# w_n2950_n2382# 0.18803f
C295 a_n52_n2172# w_n2950_n2382# 0.18803f
C296 w_n2950_n2382# a_n1084_n2172# 0.18803f
C297 w_n2950_n2382# a_n1772_n2172# 0.18805f
C298 a_1668_1260# a_2012_1260# 0.14043f
C299 a_n2012_n2264# a_n2116_n2172# 0.10756f
C300 a_n2460_n2172# w_n2950_n2382# 0.18809f
C301 w_n2950_n2382# a_2700_n2172# 0.59408f
C302 a_292_1260# a_52_1168# 0.10756f
C303 a_2460_n2264# w_n2950_n2382# 0.61304f
C304 w_n2950_n2382# a_2012_n2172# 0.18806f
C305 w_n2950_n2382# a_1428_n2264# 0.56987f
C306 a_396_n1120# a_740_n1120# 0.05997f
C307 w_n2950_n2382# a_n636_1168# 0.56949f
C308 a_n2012_24# a_n2012_1168# 0.22367f
C309 w_n2950_n2382# a_1324_n2172# 0.18804f
C310 a_292_1260# a_n52_1260# 0.14043f
C311 w_n2950_n2382# a_636_n2172# 0.18803f
C312 a_n740_n2172# w_n2950_n2382# 0.18803f
C313 a_396_1168# a_636_1260# 0.10756f
C314 w_n2950_n2382# a_n1428_n2172# 0.18804f
C315 a_n2356_24# a_n2012_24# 0.05997f
C316 w_n2950_n2382# a_n2116_n2172# 0.18806f
C317 a_2012_1260# a_2356_1260# 0.14043f
C318 a_n2700_24# w_n2950_n2382# 0.33982f
C319 a_n1084_n1028# a_n740_n1028# 0.14043f
C320 a_740_1168# a_980_1260# 0.10756f
C321 a_n2788_n2172# w_n2950_n2382# 0.59408f
C322 a_2116_n2264# w_n2950_n2382# 0.57107f
C323 a_292_1260# w_n2950_n2382# 0.18803f
C324 a_n1084_n1028# a_n1428_n1028# 0.14043f
C325 a_740_1168# a_1084_1168# 0.05997f
C326 a_n2700_24# a_n2460_116# 0.10756f
C327 a_636_n1028# a_740_n1120# 0.10756f
C328 w_n2950_n2382# a_980_1260# 0.18803f
C329 a_n1428_1260# w_n2950_n2382# 0.18804f
C330 a_n1772_n1028# a_n1428_n1028# 0.14043f
C331 a_2116_n1120# a_2116_24# 0.22367f
C332 a_n1428_1260# a_n1668_1168# 0.10756f
C333 w_n2950_n2382# a_1084_1168# 0.56955f
C334 a_n292_1168# a_52_1168# 0.05997f
C335 a_1668_1260# a_1772_1168# 0.10756f
C336 w_n2950_n2382# a_n1324_1168# 0.56955f
C337 a_2356_1260# a_2700_1260# 0.14043f
C338 a_740_n2264# a_740_n1120# 0.22367f
C339 a_1668_1260# w_n2950_n2382# 0.18805f
C340 a_n1668_1168# a_n1324_1168# 0.05997f
C341 a_n292_1168# a_n52_1260# 0.10756f
C342 a_396_n1120# a_396_n2264# 0.22367f
C343 a_n2700_24# a_n2788_116# 0.10756f
C344 a_636_n1028# a_396_n1120# 0.10756f
C345 a_n2700_1168# a_n2356_1168# 0.05997f
C346 a_396_1168# a_52_1168# 0.05997f
C347 a_n396_1260# a_n52_1260# 0.14043f
C348 w_n2950_n2382# a_n2116_n1028# 0.16695f
C349 a_1772_24# a_1772_n1120# 0.22367f
C350 a_n980_1168# w_n2950_n2382# 0.56949f
C351 a_2700_1260# a_2460_1168# 0.10756f
C352 a_n740_n1028# a_n396_n1028# 0.14043f
C353 a_1428_1168# a_1324_1260# 0.10756f
C354 w_n2950_n2382# a_n292_1168# 0.56949f
C355 w_n2950_n2382# a_2356_1260# 0.18809f
C356 a_2460_n1120# a_2700_n1028# 0.10756f
C357 a_396_1168# a_740_1168# 0.05997f
C358 a_740_n1120# a_980_n1028# 0.10756f
C359 w_n2950_n2382# a_n2700_1168# 0.61304f
C360 a_292_n1028# a_396_n1120# 0.10756f
C361 w_n2950_n2382# a_n396_1260# 0.18803f
C362 a_n2700_n1120# a_n2700_24# 0.22367f
C363 w_n2950_n2382# a_n2460_n1028# 0.16699f
C364 a_n2012_1168# a_n2356_1168# 0.05997f
C365 a_396_1168# w_n2950_n2382# 0.56949f
C366 a_740_n1120# w_n2950_n2382# 0.29627f
C367 a_n2788_n1028# w_n2950_n2382# 0.57484f
C368 a_n2012_24# a_n1668_24# 0.05997f
C369 a_n2700_n2264# a_n2356_n2264# 0.05997f
C370 w_n2950_n2382# a_2460_1168# 0.61304f
C371 a_740_n2264# a_1084_n2264# 0.05997f
C372 a_1084_24# a_1084_n1120# 0.22367f
C373 a_n2460_116# a_n2460_n1028# 0.0083f
C374 a_n2356_24# a_n2356_1168# 0.22367f
C375 w_n2950_n2382# a_n2012_24# 0.29695f
C376 a_740_n2264# a_396_n2264# 0.05997f
C377 a_n740_n1028# w_n2950_n2382# 0.16693f
C378 a_2460_n1120# a_2356_n1028# 0.10756f
C379 a_1668_n1028# a_2012_n1028# 0.14043f
C380 a_52_n2264# a_396_n2264# 0.05997f
C381 w_n2950_n2382# a_n1428_n1028# 0.16693f
C382 a_292_n1028# a_636_n1028# 0.14043f
C383 w_n2950_n2382# a_n2012_1168# 0.57017f
C384 a_1428_24# a_1428_n1120# 0.22367f
C385 a_1668_116# a_1668_1260# 0.0083f
C386 a_52_n2264# a_n292_n2264# 0.05997f
C387 a_292_n1028# a_n52_n1028# 0.14043f
C388 a_740_1168# a_636_1260# 0.10756f
C389 a_396_n1120# w_n2950_n2382# 0.29627f
C390 a_n2460_1260# a_n2788_1260# 0.14043f
C391 a_n2012_n2264# a_n2356_n2264# 0.05997f
C392 a_2460_n1120# w_n2950_n2382# 0.33982f
C393 a_n2012_1168# a_n1668_1168# 0.05997f
C394 a_n396_n1028# a_n52_n1028# 0.14043f
C395 a_n636_n2264# a_n292_n2264# 0.05997f
C396 a_n980_n2264# a_n636_n2264# 0.05997f
C397 a_n1324_n2264# a_n980_n2264# 0.05997f
C398 a_n2356_24# w_n2950_n2382# 0.29785f
C399 a_n1084_n1028# w_n2950_n2382# 0.16693f
C400 a_2012_n1028# a_2356_n1028# 0.14043f
C401 a_n2788_n1028# a_n2788_116# 0.0083f
C402 a_636_1260# w_n2950_n2382# 0.18803f
C403 a_n1324_n2264# a_n1668_n2264# 0.05997f
C404 a_1668_n1028# a_1324_n1028# 0.14043f
C405 w_n2950_n2382# a_n1772_n1028# 0.16694f
C406 a_636_n1028# a_980_n1028# 0.14043f
C407 a_n2356_24# a_n2460_116# 0.10756f
C408 w_n2950_n2382# a_1324_1260# 0.18804f
C409 a_1428_1168# a_1772_1168# 0.05997f
C410 w_n2950_n2382# a_n2356_n2264# 0.57107f
C411 a_n2012_n2264# a_n1668_n2264# 0.05997f
C412 a_1084_n2264# w_n2950_n2382# 0.56955f
C413 w_n2950_n2382# a_1428_1168# 0.56987f
C414 a_2012_n1028# w_n2950_n2382# 0.16695f
C415 w_n2950_n2382# a_396_n2264# 0.56949f
C416 a_2012_1260# a_1772_1168# 0.10756f
C417 a_636_n1028# w_n2950_n2382# 0.16693f
C418 a_n2116_116# a_n2116_n1028# 0.0083f
C419 a_2356_n1028# a_2700_n1028# 0.14043f
C420 a_2012_1260# w_n2950_n2382# 0.18806f
C421 w_n2950_n2382# a_n52_n1028# 0.16693f
C422 a_n980_n2264# w_n2950_n2382# 0.56949f
C423 a_n1428_1260# a_n1428_116# 0.0083f
C424 w_n2950_n2382# a_n292_n2264# 0.56949f
C425 a_n2700_n1120# a_n2460_n1028# 0.10756f
C426 a_980_116# a_980_1260# 0.0083f
C427 a_n2116_n1028# a_n2012_n1120# 0.10756f
C428 a_52_1168# a_n52_1260# 0.10756f
C429 a_980_n1028# a_1324_n1028# 0.14043f
C430 a_292_1260# a_292_116# 0.0083f
C431 a_n2700_n1120# a_n2788_n1028# 0.10756f
C432 a_n1772_116# a_n2012_24# 0.10756f
C433 w_n2950_n2382# a_n1668_n2264# 0.56987f
C434 w_n2950_n2382# a_n2700_n2264# 0.61304f
C435 a_740_n2264# w_n2950_n2382# 0.56949f
C436 w_n2950_n2382# a_2700_n1028# 0.57484f
C437 w_n2950_n2382# a_52_n2264# 0.56949f
C438 a_1668_n1028# w_n2950_n2382# 0.16694f
C439 a_n396_116# a_n396_1260# 0.0083f
C440 a_1324_n1028# w_n2950_n2382# 0.16693f
C441 a_292_n1028# w_n2950_n2382# 0.16693f
C442 a_n1428_n1028# a_n1324_n1120# 0.10756f
C443 w_n2950_n2382# a_n636_n2264# 0.56949f
C444 w_n2950_n2382# a_52_1168# 0.56949f
C445 w_n2950_n2382# a_n396_n1028# 0.16693f
C446 w_n2950_n2382# a_2700_1260# 0.59408f
C447 a_n1084_1260# a_n1428_1260# 0.14043f
C448 a_n1324_n2264# w_n2950_n2382# 0.56955f
C449 a_n2116_n1028# a_n2356_n1120# 0.10756f
C450 a_n2116_1260# a_n2460_1260# 0.14043f
C451 w_n2950_n2382# a_n2356_1168# 0.57107f
C452 a_n2116_116# a_n2012_24# 0.10756f
C453 w_n2950_n2382# a_n2012_n2264# 0.57017f
C454 w_n2950_n2382# a_n52_1260# 0.18803f
C455 a_n1084_1260# a_n1324_1168# 0.10756f
C456 a_n1084_n1028# a_n1324_n1120# 0.10756f
C457 w_n2950_n2382# a_2356_n1028# 0.16699f
C458 a_n2012_24# a_n2012_n1120# 0.22367f
C459 a_n1772_116# a_n1772_n1028# 0.0083f
C460 a_980_n1028# w_n2950_n2382# 0.16693f
C461 a_740_1168# w_n2950_n2382# 0.56949f
C462 a_n1428_n1028# a_n1668_n1120# 0.10756f
C463 a_2356_116# a_2356_1260# 0.0083f
C464 w_n2950_n2382# a_1772_1168# 0.57017f
C465 w_n2950_n2382# a_n1668_24# 0.29665f
C466 a_n2460_n1028# a_n2356_n1120# 0.10756f
C467 a_n1324_24# a_n1324_1168# 0.22367f
C468 a_n2356_24# a_n2116_116# 0.10756f
C469 a_n636_24# a_n636_1168# 0.22367f
C470 a_n1084_1260# a_n980_1168# 0.10756f
C471 a_n740_n1028# a_n740_116# 0.0083f
C472 a_n1668_24# a_n1668_1168# 0.22367f
C473 w_n2950_n2382# a_n1668_1168# 0.56987f
C474 w_n2950_n2382# a_n2460_116# 0.16699f
C475 a_n1084_n1028# a_n1084_116# 0.0083f
C476 a_n1772_n1028# a_n1668_n1120# 0.10756f
C477 a_1324_116# a_1324_1260# 0.0083f
C478 a_n2012_n1120# a_n1772_n1028# 0.10756f
C479 a_n2700_n1120# a_n2700_n2264# 0.22367f
C480 a_n1428_116# a_n1428_n1028# 0.0083f
C481 a_1668_116# a_1668_n1028# 0.0083f
C482 a_1084_24# a_1084_1168# 0.22367f
C483 a_2700_n2172# VSUBS 0.01781f
C484 a_2356_n2172# VSUBS 0.03047f
C485 a_2012_n2172# VSUBS 0.02532f
C486 a_1668_n2172# VSUBS 0.02532f
C487 a_1324_n2172# VSUBS 0.02532f
C488 a_980_n2172# VSUBS 0.02532f
C489 a_636_n2172# VSUBS 0.02532f
C490 a_292_n2172# VSUBS 0.02532f
C491 a_n52_n2172# VSUBS 0.02532f
C492 a_n396_n2172# VSUBS 0.02532f
C493 a_n740_n2172# VSUBS 0.02532f
C494 a_n1084_n2172# VSUBS 0.02532f
C495 a_n1428_n2172# VSUBS 0.02532f
C496 a_n1772_n2172# VSUBS 0.02532f
C497 a_n2116_n2172# VSUBS 0.02532f
C498 a_n2460_n2172# VSUBS 0.03047f
C499 a_n2788_n2172# VSUBS 0.01781f
C500 a_2700_n1028# VSUBS 0.00515f
C501 a_2356_n1028# VSUBS 0.00515f
C502 a_n2460_n1028# VSUBS 0.00515f
C503 a_n2788_n1028# VSUBS 0.00515f
C504 a_2700_116# VSUBS 0.00515f
C505 a_2356_116# VSUBS 0.00515f
C506 a_n2460_116# VSUBS 0.00515f
C507 a_n2788_116# VSUBS 0.00515f
C508 a_2700_1260# VSUBS 0.01781f
C509 a_2356_1260# VSUBS 0.03047f
C510 a_2012_1260# VSUBS 0.02532f
C511 a_1668_1260# VSUBS 0.02532f
C512 a_1324_1260# VSUBS 0.02532f
C513 a_980_1260# VSUBS 0.02532f
C514 a_636_1260# VSUBS 0.02532f
C515 a_292_1260# VSUBS 0.02532f
C516 a_n52_1260# VSUBS 0.02532f
C517 a_n396_1260# VSUBS 0.02532f
C518 a_n740_1260# VSUBS 0.02532f
C519 a_n1084_1260# VSUBS 0.02532f
C520 a_n1428_1260# VSUBS 0.02532f
C521 a_n1772_1260# VSUBS 0.02532f
C522 a_n2116_1260# VSUBS 0.02532f
C523 a_n2460_1260# VSUBS 0.03047f
C524 a_n2788_1260# VSUBS 0.01781f
C525 w_n2950_n2382# VSUBS 87.6741f
.ends

.subckt nfet_03v3_TNDTXF a_n52_n500# a_n852_n500# a_356_n500# a_52_n592# a_560_n500#
+ a_n152_n592# a_152_n500# a_n664_n500# a_664_n592# a_n764_n592# a_n256_n500# a_n990_n686#
+ a_n460_n500# a_256_n592# a_764_n500# a_n356_n592# a_460_n592# a_n560_n592#
X0 a_560_n500# a_460_n592# a_356_n500# a_n990_n686# nfet_03v3 ad=1.3p pd=5.52u as=1.3p ps=5.52u w=5u l=0.5u
X1 a_n256_n500# a_n356_n592# a_n460_n500# a_n990_n686# nfet_03v3 ad=1.3p pd=5.52u as=1.3p ps=5.52u w=5u l=0.5u
X2 a_356_n500# a_256_n592# a_152_n500# a_n990_n686# nfet_03v3 ad=1.3p pd=5.52u as=1.3p ps=5.52u w=5u l=0.5u
X3 a_n664_n500# a_n764_n592# a_n852_n500# a_n990_n686# nfet_03v3 ad=1.3p pd=5.52u as=2.2p ps=10.88u w=5u l=0.5u
X4 a_152_n500# a_52_n592# a_n52_n500# a_n990_n686# nfet_03v3 ad=1.3p pd=5.52u as=1.3p ps=5.52u w=5u l=0.5u
X5 a_764_n500# a_664_n592# a_560_n500# a_n990_n686# nfet_03v3 ad=2.2p pd=10.88u as=1.3p ps=5.52u w=5u l=0.5u
X6 a_n460_n500# a_n560_n592# a_n664_n500# a_n990_n686# nfet_03v3 ad=1.3p pd=5.52u as=1.3p ps=5.52u w=5u l=0.5u
X7 a_n52_n500# a_n152_n592# a_n256_n500# a_n990_n686# nfet_03v3 ad=1.3p pd=5.52u as=1.3p ps=5.52u w=5u l=0.5u
C0 a_152_n500# a_52_n592# 0.06481f
C1 a_52_n592# a_256_n592# 0.05997f
C2 a_n152_n592# a_52_n592# 0.05997f
C3 a_n152_n592# a_n356_n592# 0.05997f
C4 a_n560_n592# a_n356_n592# 0.05997f
C5 a_460_n592# a_256_n592# 0.05997f
C6 a_152_n500# a_256_n592# 0.06481f
C7 a_n52_n500# a_52_n592# 0.06481f
C8 a_460_n592# a_664_n592# 0.05997f
C9 a_n764_n592# a_n560_n592# 0.05997f
C10 a_n256_n500# a_n356_n592# 0.06481f
C11 a_n460_n500# a_n356_n592# 0.06481f
C12 a_n52_n500# a_152_n500# 0.29306f
C13 a_n664_n500# a_n764_n592# 0.06481f
C14 a_n852_n500# a_n764_n592# 0.06481f
C15 a_n52_n500# a_n152_n592# 0.06481f
C16 a_n256_n500# a_n152_n592# 0.06481f
C17 a_n460_n500# a_n560_n592# 0.06481f
C18 a_n664_n500# a_n560_n592# 0.06481f
C19 a_n52_n500# a_n256_n500# 0.29306f
C20 a_n460_n500# a_n256_n500# 0.29306f
C21 a_n664_n500# a_n460_n500# 0.29306f
C22 a_n664_n500# a_n852_n500# 0.29306f
C23 a_356_n500# a_460_n592# 0.06481f
C24 a_356_n500# a_152_n500# 0.29306f
C25 a_460_n592# a_560_n500# 0.06481f
C26 a_356_n500# a_256_n592# 0.06481f
C27 a_560_n500# a_664_n592# 0.06481f
C28 a_664_n592# a_764_n500# 0.06481f
C29 a_356_n500# a_560_n500# 0.29306f
C30 a_560_n500# a_764_n500# 0.29306f
C31 a_764_n500# a_n990_n686# 0.6677f
C32 a_560_n500# a_n990_n686# 0.24078f
C33 a_356_n500# a_n990_n686# 0.2159f
C34 a_152_n500# a_n990_n686# 0.21558f
C35 a_n52_n500# a_n990_n686# 0.2155f
C36 a_n256_n500# a_n990_n686# 0.21558f
C37 a_n460_n500# a_n990_n686# 0.2159f
C38 a_n664_n500# a_n990_n686# 0.24078f
C39 a_n852_n500# a_n990_n686# 0.6677f
.ends

.subckt pfet_03v3_BXNJAZ a_256_n912# a_n52_n820# a_356_n820# a_n868_n820# a_n356_n912#
+ a_460_n912# a_560_n820# a_n560_n912# a_52_n912# a_152_n820# a_n664_n820# a_868_n912#
+ a_n152_n912# w_n1218_n1030# a_968_n820# a_n968_n912# a_n1056_n820# a_n256_n820#
+ a_n460_n820# a_664_n912# a_764_n820# a_n764_n912# VSUBS
X0 a_n868_n820# a_n968_n912# a_n1056_n820# w_n1218_n1030# pfet_03v3 ad=2.132p pd=8.72u as=3.608p ps=17.28u w=8.2u l=0.5u
X1 a_560_n820# a_460_n912# a_356_n820# w_n1218_n1030# pfet_03v3 ad=2.132p pd=8.72u as=2.132p ps=8.72u w=8.2u l=0.5u
X2 a_968_n820# a_868_n912# a_764_n820# w_n1218_n1030# pfet_03v3 ad=3.608p pd=17.28u as=2.132p ps=8.72u w=8.2u l=0.5u
X3 a_n256_n820# a_n356_n912# a_n460_n820# w_n1218_n1030# pfet_03v3 ad=2.132p pd=8.72u as=2.132p ps=8.72u w=8.2u l=0.5u
X4 a_356_n820# a_256_n912# a_152_n820# w_n1218_n1030# pfet_03v3 ad=2.132p pd=8.72u as=2.132p ps=8.72u w=8.2u l=0.5u
X5 a_n664_n820# a_n764_n912# a_n868_n820# w_n1218_n1030# pfet_03v3 ad=2.132p pd=8.72u as=2.132p ps=8.72u w=8.2u l=0.5u
X6 a_152_n820# a_52_n912# a_n52_n820# w_n1218_n1030# pfet_03v3 ad=2.132p pd=8.72u as=2.132p ps=8.72u w=8.2u l=0.5u
X7 a_764_n820# a_664_n912# a_560_n820# w_n1218_n1030# pfet_03v3 ad=2.132p pd=8.72u as=2.132p ps=8.72u w=8.2u l=0.5u
X8 a_n460_n820# a_n560_n912# a_n664_n820# w_n1218_n1030# pfet_03v3 ad=2.132p pd=8.72u as=2.132p ps=8.72u w=8.2u l=0.5u
X9 a_n52_n820# a_n152_n912# a_n256_n820# w_n1218_n1030# pfet_03v3 ad=2.132p pd=8.72u as=2.132p ps=8.72u w=8.2u l=0.5u
C0 a_356_n820# w_n1218_n1030# 0.18233f
C1 a_n256_n820# a_n152_n912# 0.10645f
C2 a_n256_n820# a_n356_n912# 0.10645f
C3 a_152_n820# w_n1218_n1030# 0.18232f
C4 a_n256_n820# w_n1218_n1030# 0.18232f
C5 a_52_n912# a_152_n820# 0.10645f
C6 a_n152_n912# a_n52_n820# 0.10645f
C7 a_764_n820# a_664_n912# 0.10645f
C8 a_n52_n820# w_n1218_n1030# 0.18232f
C9 a_52_n912# a_n52_n820# 0.10645f
C10 a_764_n820# a_968_n820# 0.48137f
C11 a_764_n820# a_868_n912# 0.10645f
C12 a_152_n820# a_356_n820# 0.48137f
C13 a_764_n820# w_n1218_n1030# 0.18238f
C14 a_664_n912# a_560_n820# 0.10645f
C15 a_n52_n820# a_152_n820# 0.48137f
C16 a_n256_n820# a_n52_n820# 0.48137f
C17 a_460_n912# a_560_n820# 0.10645f
C18 a_560_n820# w_n1218_n1030# 0.18234f
C19 a_356_n820# a_560_n820# 0.48137f
C20 a_764_n820# a_560_n820# 0.48137f
C21 a_460_n912# a_256_n912# 0.05997f
C22 a_256_n912# w_n1218_n1030# 0.1769f
C23 a_256_n912# a_52_n912# 0.05997f
C24 a_n664_n820# a_n460_n820# 0.48137f
C25 a_n460_n820# a_n356_n912# 0.10645f
C26 a_n560_n912# a_n460_n820# 0.10645f
C27 a_n460_n820# w_n1218_n1030# 0.18233f
C28 a_256_n912# a_356_n820# 0.10645f
C29 a_256_n912# a_152_n820# 0.10645f
C30 a_n256_n820# a_n460_n820# 0.48137f
C31 a_460_n912# a_664_n912# 0.05997f
C32 a_664_n912# a_868_n912# 0.05997f
C33 a_968_n820# a_868_n912# 0.10645f
C34 a_664_n912# w_n1218_n1030# 0.1775f
C35 a_n1056_n820# a_n968_n912# 0.10645f
C36 a_n1056_n820# a_n868_n820# 0.48137f
C37 a_968_n820# w_n1218_n1030# 0.9735f
C38 a_460_n912# w_n1218_n1030# 0.17701f
C39 a_n1056_n820# w_n1218_n1030# 0.9735f
C40 a_868_n912# w_n1218_n1030# 0.21652f
C41 a_n968_n912# a_n868_n820# 0.10645f
C42 a_n152_n912# a_n356_n912# 0.05997f
C43 a_n560_n912# a_n664_n820# 0.10645f
C44 a_n664_n820# a_n868_n820# 0.48137f
C45 a_n764_n912# a_n968_n912# 0.05997f
C46 a_n968_n912# w_n1218_n1030# 0.21652f
C47 a_n560_n912# a_n356_n912# 0.05997f
C48 a_n664_n820# a_n764_n912# 0.10645f
C49 a_n152_n912# w_n1218_n1030# 0.17683f
C50 a_n664_n820# w_n1218_n1030# 0.18234f
C51 a_52_n912# a_n152_n912# 0.05997f
C52 a_n560_n912# a_n764_n912# 0.05997f
C53 a_n764_n912# a_n868_n820# 0.10645f
C54 w_n1218_n1030# a_n868_n820# 0.18238f
C55 a_n356_n912# w_n1218_n1030# 0.1769f
C56 a_n560_n912# w_n1218_n1030# 0.17701f
C57 a_n764_n912# w_n1218_n1030# 0.1775f
C58 a_52_n912# w_n1218_n1030# 0.17683f
C59 a_460_n912# a_356_n820# 0.10645f
C60 a_968_n820# VSUBS 0.04447f
C61 a_764_n820# VSUBS 0.07206f
C62 a_560_n820# VSUBS 0.06691f
C63 a_356_n820# VSUBS 0.06691f
C64 a_152_n820# VSUBS 0.06691f
C65 a_n52_n820# VSUBS 0.06691f
C66 a_n256_n820# VSUBS 0.06691f
C67 a_n460_n820# VSUBS 0.06691f
C68 a_n664_n820# VSUBS 0.06691f
C69 a_n868_n820# VSUBS 0.07206f
C70 a_n1056_n820# VSUBS 0.04447f
C71 w_n1218_n1030# VSUBS 15.6819f
.ends

.subckt nfet_03v3_C4MKPC a_n52_n200# a_n862_n386# a_52_n292# a_636_n200# a_n396_n200#
+ a_396_n292# a_n724_n200# a_n292_n292# a_292_n200# a_n636_n292#
X0 a_n52_n200# a_n292_n292# a_n396_n200# a_n862_n386# nfet_03v3 ad=0.52p pd=2.52u as=0.52p ps=2.52u w=2u l=1.2u
X1 a_292_n200# a_52_n292# a_n52_n200# a_n862_n386# nfet_03v3 ad=0.52p pd=2.52u as=0.52p ps=2.52u w=2u l=1.2u
X2 a_636_n200# a_396_n292# a_292_n200# a_n862_n386# nfet_03v3 ad=0.88p pd=4.88u as=0.52p ps=2.52u w=2u l=1.2u
X3 a_n396_n200# a_n636_n292# a_n724_n200# a_n862_n386# nfet_03v3 ad=0.52p pd=2.52u as=0.88p ps=4.88u w=2u l=1.2u
C0 a_n52_n200# a_n396_n200# 0.06124f
C1 a_n724_n200# a_n396_n200# 0.06124f
C2 a_292_n200# a_52_n292# 0.04691f
C3 a_n292_n292# a_52_n292# 0.05997f
C4 a_n636_n292# a_n292_n292# 0.05997f
C5 a_636_n200# a_292_n200# 0.06124f
C6 a_n52_n200# a_52_n292# 0.04691f
C7 a_n52_n200# a_292_n200# 0.06124f
C8 a_n52_n200# a_n292_n292# 0.04691f
C9 a_n724_n200# a_n636_n292# 0.04691f
C10 a_52_n292# a_396_n292# 0.05997f
C11 a_292_n200# a_396_n292# 0.04691f
C12 a_636_n200# a_396_n292# 0.04691f
C13 a_n396_n200# a_n292_n292# 0.04691f
C14 a_n396_n200# a_n636_n292# 0.04691f
C15 a_636_n200# a_n862_n386# 0.69067f
C16 a_292_n200# a_n862_n386# 0.8969f
C17 a_n52_n200# a_n862_n386# 0.87089f
C18 a_n396_n200# a_n862_n386# 0.8969f
C19 a_n724_n200# a_n862_n386# 0.69067f
.ends

.subckt pfet_03v3_6BU64J a_292_n1676# a_n980_n1768# a_740_24# a_n1324_24# a_n1428_n1676#
+ a_1668_n1676# a_n1756_n1676# a_n980_24# a_980_n1676# a_n1084_n1676# a_52_24# a_n396_n1676#
+ a_n740_n1676# a_396_24# a_52_n1768# a_n636_24# a_n396_116# a_1428_24# a_n1084_116#
+ a_292_116# a_n1668_24# a_980_116# a_n740_116# a_1428_n1768# a_n1324_n1768# a_n52_116#
+ a_740_n1768# a_396_n1768# a_n636_n1768# w_n1918_n1886# a_1084_n1768# a_1668_116#
+ a_n1756_116# a_n292_n1768# a_n1428_116# a_n292_24# a_636_116# a_n1668_n1768# a_636_n1676#
+ a_n52_n1676# a_1324_116# a_1084_24# a_1324_n1676# VSUBS
X0 a_1324_116# a_1084_24# a_980_116# w_n1918_n1886# pfet_03v3 ad=2.028p pd=8.32u as=2.028p ps=8.32u w=7.8u l=1.2u
X1 a_n1428_n1676# a_n1668_n1768# a_n1756_n1676# w_n1918_n1886# pfet_03v3 ad=2.028p pd=8.32u as=3.432p ps=16.48u w=7.8u l=1.2u
X2 a_1668_116# a_1428_24# a_1324_116# w_n1918_n1886# pfet_03v3 ad=3.432p pd=16.48u as=2.028p ps=8.32u w=7.8u l=1.2u
X3 a_636_116# a_396_24# a_292_116# w_n1918_n1886# pfet_03v3 ad=2.028p pd=8.32u as=2.028p ps=8.32u w=7.8u l=1.2u
X4 a_980_116# a_740_24# a_636_116# w_n1918_n1886# pfet_03v3 ad=2.028p pd=8.32u as=2.028p ps=8.32u w=7.8u l=1.2u
X5 a_n1428_116# a_n1668_24# a_n1756_116# w_n1918_n1886# pfet_03v3 ad=2.028p pd=8.32u as=3.432p ps=16.48u w=7.8u l=1.2u
X6 a_n396_n1676# a_n636_n1768# a_n740_n1676# w_n1918_n1886# pfet_03v3 ad=2.028p pd=8.32u as=2.028p ps=8.32u w=7.8u l=1.2u
X7 a_n1084_116# a_n1324_24# a_n1428_116# w_n1918_n1886# pfet_03v3 ad=2.028p pd=8.32u as=2.028p ps=8.32u w=7.8u l=1.2u
X8 a_n52_n1676# a_n292_n1768# a_n396_n1676# w_n1918_n1886# pfet_03v3 ad=2.028p pd=8.32u as=2.028p ps=8.32u w=7.8u l=1.2u
X9 a_n740_116# a_n980_24# a_n1084_116# w_n1918_n1886# pfet_03v3 ad=2.028p pd=8.32u as=2.028p ps=8.32u w=7.8u l=1.2u
X10 a_n1084_n1676# a_n1324_n1768# a_n1428_n1676# w_n1918_n1886# pfet_03v3 ad=2.028p pd=8.32u as=2.028p ps=8.32u w=7.8u l=1.2u
X11 a_980_n1676# a_740_n1768# a_636_n1676# w_n1918_n1886# pfet_03v3 ad=2.028p pd=8.32u as=2.028p ps=8.32u w=7.8u l=1.2u
X12 a_n52_116# a_n292_24# a_n396_116# w_n1918_n1886# pfet_03v3 ad=2.028p pd=8.32u as=2.028p ps=8.32u w=7.8u l=1.2u
X13 a_292_n1676# a_52_n1768# a_n52_n1676# w_n1918_n1886# pfet_03v3 ad=2.028p pd=8.32u as=2.028p ps=8.32u w=7.8u l=1.2u
X14 a_n396_116# a_n636_24# a_n740_116# w_n1918_n1886# pfet_03v3 ad=2.028p pd=8.32u as=2.028p ps=8.32u w=7.8u l=1.2u
X15 a_292_116# a_52_24# a_n52_116# w_n1918_n1886# pfet_03v3 ad=2.028p pd=8.32u as=2.028p ps=8.32u w=7.8u l=1.2u
X16 a_1668_n1676# a_1428_n1768# a_1324_n1676# w_n1918_n1886# pfet_03v3 ad=3.432p pd=16.48u as=2.028p ps=8.32u w=7.8u l=1.2u
X17 a_636_n1676# a_396_n1768# a_292_n1676# w_n1918_n1886# pfet_03v3 ad=2.028p pd=8.32u as=2.028p ps=8.32u w=7.8u l=1.2u
X18 a_n740_n1676# a_n980_n1768# a_n1084_n1676# w_n1918_n1886# pfet_03v3 ad=2.028p pd=8.32u as=2.028p ps=8.32u w=7.8u l=1.2u
X19 a_1324_n1676# a_1084_n1768# a_980_n1676# w_n1918_n1886# pfet_03v3 ad=2.028p pd=8.32u as=2.028p ps=8.32u w=7.8u l=1.2u
C0 a_1084_24# a_980_116# 0.18432f
C1 a_1084_24# a_1324_116# 0.18432f
C2 a_740_24# a_396_24# 0.05997f
C3 w_n1918_n1886# a_n980_n1768# 0.57695f
C4 a_n1084_n1676# a_n1084_116# 0.0083f
C5 a_1428_24# a_1324_116# 0.18432f
C6 a_n1428_116# a_n1428_n1676# 0.0083f
C7 a_n636_24# a_n636_n1768# 0.22367f
C8 a_n980_24# a_n980_n1768# 0.22367f
C9 w_n1918_n1886# a_n52_n1676# 0.30563f
C10 a_1428_24# a_1668_116# 0.18432f
C11 a_1084_n1768# a_1084_24# 0.22367f
C12 w_n1918_n1886# a_1428_n1768# 0.61982f
C13 a_n292_24# a_52_24# 0.05997f
C14 a_n52_116# a_n52_n1676# 0.0083f
C15 w_n1918_n1886# a_n636_n1768# 0.57665f
C16 a_n1756_n1676# a_n1756_116# 0.0083f
C17 a_n636_24# a_n292_24# 0.05997f
C18 w_n1918_n1886# a_52_24# 0.57633f
C19 a_n52_116# a_52_24# 0.18432f
C20 a_n292_24# w_n1918_n1886# 0.57633f
C21 a_636_n1676# a_396_n1768# 0.18432f
C22 a_1428_24# a_1428_n1768# 0.22367f
C23 a_n52_116# a_n292_24# 0.18432f
C24 a_n636_24# w_n1918_n1886# 0.57665f
C25 w_n1918_n1886# a_n1668_24# 0.61982f
C26 a_n636_24# a_n980_24# 0.05997f
C27 a_396_n1768# a_292_n1676# 0.18432f
C28 a_n1668_24# a_n1324_24# 0.05997f
C29 a_n52_116# w_n1918_n1886# 0.30563f
C30 w_n1918_n1886# a_n980_24# 0.57695f
C31 w_n1918_n1886# a_n1324_24# 0.57784f
C32 a_396_24# a_396_n1768# 0.22367f
C33 w_n1918_n1886# a_740_24# 0.57695f
C34 a_n980_24# a_n1324_24# 0.05997f
C35 w_n1918_n1886# a_n1084_116# 0.30565f
C36 a_n1668_24# a_n1756_116# 0.18432f
C37 a_1084_24# w_n1918_n1886# 0.57784f
C38 w_n1918_n1886# a_n1756_116# 1.00127f
C39 a_n1428_116# a_n1668_24# 0.18432f
C40 a_1428_24# w_n1918_n1886# 0.61982f
C41 a_n980_24# a_n1084_116# 0.18432f
C42 a_n1428_116# w_n1918_n1886# 0.30569f
C43 a_n1084_116# a_n1324_24# 0.18432f
C44 a_1084_24# a_740_24# 0.05997f
C45 a_n1428_116# a_n1324_24# 0.18432f
C46 a_1084_24# a_1428_24# 0.05997f
C47 a_n1428_116# a_n1084_116# 0.24064f
C48 a_n1428_116# a_n1756_116# 0.24064f
C49 w_n1918_n1886# a_396_n1768# 0.57665f
C50 a_740_n1768# a_980_n1676# 0.18432f
C51 a_52_n1768# a_292_n1676# 0.18432f
C52 a_740_n1768# a_636_n1676# 0.18432f
C53 a_n1668_n1768# a_n1324_n1768# 0.05997f
C54 a_n1428_n1676# a_n1668_n1768# 0.18432f
C55 a_52_n1768# a_n292_n1768# 0.05997f
C56 a_n1756_n1676# a_n1668_n1768# 0.18432f
C57 a_1084_n1768# a_740_n1768# 0.05997f
C58 a_n52_n1676# a_52_n1768# 0.18432f
C59 a_52_24# a_52_n1768# 0.22367f
C60 a_1324_n1676# a_1668_n1676# 0.24064f
C61 a_n740_116# a_n740_n1676# 0.0083f
C62 a_1324_n1676# a_980_n1676# 0.24064f
C63 a_636_n1676# a_980_n1676# 0.24064f
C64 a_636_116# a_636_n1676# 0.0083f
C65 a_980_n1676# a_980_116# 0.0083f
C66 a_n396_116# a_n740_116# 0.24064f
C67 a_636_116# a_980_116# 0.24064f
C68 w_n1918_n1886# a_52_n1768# 0.57633f
C69 a_1324_116# a_1324_n1676# 0.0083f
C70 a_1668_n1676# a_1668_116# 0.0083f
C71 a_n1084_n1676# a_n740_n1676# 0.24064f
C72 a_n396_n1676# a_n740_n1676# 0.24064f
C73 a_1324_116# a_980_116# 0.24064f
C74 a_n1428_n1676# a_n1324_n1768# 0.18432f
C75 a_n1668_24# a_n1668_n1768# 0.22367f
C76 a_636_n1676# a_292_n1676# 0.24064f
C77 w_n1918_n1886# a_n1668_n1768# 0.61982f
C78 a_1084_n1768# a_1324_n1676# 0.18432f
C79 a_n396_116# a_n396_n1676# 0.0083f
C80 a_n1084_n1676# a_n1324_n1768# 0.18432f
C81 a_1084_n1768# a_980_n1676# 0.18432f
C82 a_636_116# a_292_116# 0.24064f
C83 a_n1084_n1676# a_n1428_n1676# 0.24064f
C84 w_n1918_n1886# a_740_n1768# 0.57695f
C85 a_1324_116# a_1668_116# 0.24064f
C86 a_636_116# a_396_24# 0.18432f
C87 a_n740_n1676# a_n980_n1768# 0.18432f
C88 a_n1756_n1676# a_n1428_n1676# 0.24064f
C89 a_740_n1768# a_740_24# 0.22367f
C90 a_292_116# a_292_n1676# 0.0083f
C91 a_n396_n1676# a_n292_n1768# 0.18432f
C92 a_1668_n1676# a_1428_n1768# 0.18432f
C93 a_396_24# a_292_116# 0.18432f
C94 a_n1324_n1768# a_n980_n1768# 0.05997f
C95 a_1324_n1676# a_1428_n1768# 0.18432f
C96 a_n740_n1676# a_n636_n1768# 0.18432f
C97 a_n1084_n1676# a_n980_n1768# 0.18432f
C98 a_n396_n1676# a_n52_n1676# 0.24064f
C99 a_n52_n1676# a_292_n1676# 0.24064f
C100 a_n52_n1676# a_n292_n1768# 0.18432f
C101 a_n396_n1676# a_n636_n1768# 0.18432f
C102 a_1084_n1768# a_1428_n1768# 0.05997f
C103 a_n292_n1768# a_n636_n1768# 0.05997f
C104 a_n396_116# a_n292_24# 0.18432f
C105 a_n636_24# a_n740_116# 0.18432f
C106 w_n1918_n1886# a_1668_n1676# 1.00127f
C107 a_52_24# a_292_116# 0.18432f
C108 a_396_n1768# a_52_n1768# 0.05997f
C109 a_n396_116# a_n636_24# 0.18432f
C110 w_n1918_n1886# a_n740_n1676# 0.30564f
C111 w_n1918_n1886# a_1324_n1676# 0.30569f
C112 a_396_24# a_52_24# 0.05997f
C113 a_n980_n1768# a_n636_n1768# 0.05997f
C114 w_n1918_n1886# a_636_n1676# 0.30564f
C115 w_n1918_n1886# a_980_n1676# 0.30565f
C116 w_n1918_n1886# a_n740_116# 0.30564f
C117 w_n1918_n1886# a_636_116# 0.30564f
C118 w_n1918_n1886# a_980_116# 0.30565f
C119 a_n396_116# w_n1918_n1886# 0.30564f
C120 a_n292_24# a_n292_n1768# 0.22367f
C121 w_n1918_n1886# a_n1324_n1768# 0.57784f
C122 w_n1918_n1886# a_n1428_n1676# 0.30569f
C123 a_n740_116# a_n980_24# 0.18432f
C124 a_1324_116# w_n1918_n1886# 0.30569f
C125 a_n52_116# a_n396_116# 0.24064f
C126 a_740_n1768# a_396_n1768# 0.05997f
C127 w_n1918_n1886# a_n1084_n1676# 0.30565f
C128 a_740_24# a_636_116# 0.18432f
C129 a_n1324_n1768# a_n1324_24# 0.22367f
C130 w_n1918_n1886# a_n396_n1676# 0.30564f
C131 w_n1918_n1886# a_1668_116# 1.00127f
C132 a_740_24# a_980_116# 0.18432f
C133 w_n1918_n1886# a_292_n1676# 0.30564f
C134 w_n1918_n1886# a_292_116# 0.30564f
C135 a_1084_n1768# w_n1918_n1886# 0.57784f
C136 w_n1918_n1886# a_n292_n1768# 0.57633f
C137 w_n1918_n1886# a_396_24# 0.57665f
C138 a_n740_116# a_n1084_116# 0.24064f
C139 a_n52_116# a_292_116# 0.24064f
C140 w_n1918_n1886# a_n1756_n1676# 1.00127f
C141 a_1668_n1676# VSUBS 0.02404f
C142 a_1324_n1676# VSUBS 0.04293f
C143 a_980_n1676# VSUBS 0.03777f
C144 a_636_n1676# VSUBS 0.03777f
C145 a_292_n1676# VSUBS 0.03777f
C146 a_n52_n1676# VSUBS 0.03777f
C147 a_n396_n1676# VSUBS 0.03777f
C148 a_n740_n1676# VSUBS 0.03777f
C149 a_n1084_n1676# VSUBS 0.03777f
C150 a_n1428_n1676# VSUBS 0.04293f
C151 a_n1756_n1676# VSUBS 0.02404f
C152 a_1668_116# VSUBS 0.02404f
C153 a_1324_116# VSUBS 0.04293f
C154 a_980_116# VSUBS 0.03777f
C155 a_636_116# VSUBS 0.03777f
C156 a_292_116# VSUBS 0.03777f
C157 a_n52_116# VSUBS 0.03777f
C158 a_n396_116# VSUBS 0.03777f
C159 a_n740_116# VSUBS 0.03777f
C160 a_n1084_116# VSUBS 0.03777f
C161 a_n1428_116# VSUBS 0.04293f
C162 a_n1756_116# VSUBS 0.02404f
C163 w_n1918_n1886# VSUBS 45.7966f
.ends

.subckt pfet_03v3_NRUA5E a_636_n838# a_n396_n838# a_n1324_n930# a_n292_n930# a_n636_n930#
+ a_740_n930# w_n1574_n1048# a_52_n930# a_1084_n930# a_396_n930# a_980_n838# a_n740_n838#
+ a_n1084_n838# a_292_n838# a_n52_n838# a_1324_n838# a_n1412_n838# a_n980_n930# VSUBS
X0 a_n396_n838# a_n636_n930# a_n740_n838# w_n1574_n1048# pfet_03v3 ad=2.1788p pd=8.9u as=2.1788p ps=8.9u w=8.38u l=1.2u
X1 a_n740_n838# a_n980_n930# a_n1084_n838# w_n1574_n1048# pfet_03v3 ad=2.1788p pd=8.9u as=2.1788p ps=8.9u w=8.38u l=1.2u
X2 a_n1084_n838# a_n1324_n930# a_n1412_n838# w_n1574_n1048# pfet_03v3 ad=2.1788p pd=8.9u as=3.6872p ps=17.64u w=8.38u l=1.2u
X3 a_n52_n838# a_n292_n930# a_n396_n838# w_n1574_n1048# pfet_03v3 ad=2.1788p pd=8.9u as=2.1788p ps=8.9u w=8.38u l=1.2u
X4 a_292_n838# a_52_n930# a_n52_n838# w_n1574_n1048# pfet_03v3 ad=2.1788p pd=8.9u as=2.1788p ps=8.9u w=8.38u l=1.2u
X5 a_636_n838# a_396_n930# a_292_n838# w_n1574_n1048# pfet_03v3 ad=2.1788p pd=8.9u as=2.1788p ps=8.9u w=8.38u l=1.2u
X6 a_980_n838# a_740_n930# a_636_n838# w_n1574_n1048# pfet_03v3 ad=2.1788p pd=8.9u as=2.1788p ps=8.9u w=8.38u l=1.2u
X7 a_1324_n838# a_1084_n930# a_980_n838# w_n1574_n1048# pfet_03v3 ad=3.6872p pd=17.64u as=2.1788p ps=8.9u w=8.38u l=1.2u
C0 a_636_n838# a_292_n838# 0.25858f
C1 a_636_n838# a_740_n930# 0.19805f
C2 a_636_n838# w_n1574_n1048# 0.3489f
C3 a_396_n930# a_636_n838# 0.19805f
C4 a_292_n838# w_n1574_n1048# 0.34889f
C5 a_396_n930# a_292_n838# 0.19805f
C6 a_n52_n838# a_292_n838# 0.25858f
C7 a_980_n838# a_636_n838# 0.25858f
C8 a_n740_n838# a_n980_n930# 0.19805f
C9 a_n980_n930# a_n1084_n838# 0.19805f
C10 a_n740_n838# a_n1084_n838# 0.25858f
C11 a_n740_n838# a_n396_n838# 0.25858f
C12 a_n1412_n838# a_n1084_n838# 0.25858f
C13 a_n1324_n930# a_n980_n930# 0.05997f
C14 a_n980_n930# w_n1574_n1048# 0.85112f
C15 a_n740_n838# w_n1574_n1048# 0.3489f
C16 a_n1324_n930# a_n1084_n838# 0.19805f
C17 a_n1324_n930# a_n1412_n838# 0.19805f
C18 w_n1574_n1048# a_n1084_n838# 0.34893f
C19 a_n396_n838# w_n1574_n1048# 0.34889f
C20 w_n1574_n1048# a_n1412_n838# 1.09419f
C21 a_740_n930# a_1084_n930# 0.05997f
C22 w_n1574_n1048# a_1084_n930# 0.89309f
C23 a_n52_n838# a_n396_n838# 0.25858f
C24 w_n1574_n1048# a_740_n930# 0.85112f
C25 a_n1324_n930# w_n1574_n1048# 0.89309f
C26 a_396_n930# a_740_n930# 0.05997f
C27 a_396_n930# w_n1574_n1048# 0.85023f
C28 a_n52_n838# w_n1574_n1048# 0.34889f
C29 a_1324_n838# a_1084_n930# 0.19805f
C30 a_n292_n930# a_n396_n838# 0.19805f
C31 a_1324_n838# w_n1574_n1048# 1.09419f
C32 a_52_n930# a_292_n838# 0.19805f
C33 a_n292_n930# w_n1574_n1048# 0.84998f
C34 a_980_n838# a_1084_n930# 0.19805f
C35 a_n52_n838# a_n292_n930# 0.19805f
C36 a_980_n838# a_740_n930# 0.19805f
C37 a_980_n838# w_n1574_n1048# 0.34893f
C38 a_n636_n930# a_n740_n838# 0.19805f
C39 a_n636_n930# a_n980_n930# 0.05997f
C40 a_n636_n930# a_n396_n838# 0.19805f
C41 a_n636_n930# w_n1574_n1048# 0.85023f
C42 a_980_n838# a_1324_n838# 0.25858f
C43 a_52_n930# w_n1574_n1048# 0.84998f
C44 a_396_n930# a_52_n930# 0.05997f
C45 a_n52_n838# a_52_n930# 0.19805f
C46 a_n636_n930# a_n292_n930# 0.05997f
C47 a_n292_n930# a_52_n930# 0.05997f
C48 a_1324_n838# VSUBS 0.0367f
C49 a_980_n838# VSUBS 0.06825f
C50 a_636_n838# VSUBS 0.0631f
C51 a_292_n838# VSUBS 0.0631f
C52 a_n52_n838# VSUBS 0.0631f
C53 a_n396_n838# VSUBS 0.0631f
C54 a_n740_n838# VSUBS 0.0631f
C55 a_n1084_n838# VSUBS 0.06825f
C56 a_n1412_n838# VSUBS 0.0367f
C57 w_n1574_n1048# VSUBS 21.4129f
.ends

.subckt nfet_03v3_ZTT4MX a_1428_n992# a_n980_n992# a_n1324_n992# a_n292_n992# a_n1894_n1086#
+ a_980_n900# a_n740_n900# a_n1668_n992# a_n1084_n900# a_292_n900# a_n636_n992# a_n52_n900#
+ a_740_n992# a_1324_n900# a_n1428_n900# a_n396_n900# a_52_n992# a_636_n900# a_1084_n992#
+ a_1668_n900# a_n1756_n900# a_396_n992#
X0 a_n52_n900# a_n292_n992# a_n396_n900# a_n1894_n1086# nfet_03v3 ad=2.34p pd=9.52u as=2.34p ps=9.52u w=9u l=1.2u
X1 a_n1428_n900# a_n1668_n992# a_n1756_n900# a_n1894_n1086# nfet_03v3 ad=2.34p pd=9.52u as=3.96p ps=18.88u w=9u l=1.2u
X2 a_292_n900# a_52_n992# a_n52_n900# a_n1894_n1086# nfet_03v3 ad=2.34p pd=9.52u as=2.34p ps=9.52u w=9u l=1.2u
X3 a_1668_n900# a_1428_n992# a_1324_n900# a_n1894_n1086# nfet_03v3 ad=3.96p pd=18.88u as=2.34p ps=9.52u w=9u l=1.2u
X4 a_636_n900# a_396_n992# a_292_n900# a_n1894_n1086# nfet_03v3 ad=2.34p pd=9.52u as=2.34p ps=9.52u w=9u l=1.2u
X5 a_980_n900# a_740_n992# a_636_n900# a_n1894_n1086# nfet_03v3 ad=2.34p pd=9.52u as=2.34p ps=9.52u w=9u l=1.2u
X6 a_1324_n900# a_1084_n992# a_980_n900# a_n1894_n1086# nfet_03v3 ad=2.34p pd=9.52u as=2.34p ps=9.52u w=9u l=1.2u
X7 a_n396_n900# a_n636_n992# a_n740_n900# a_n1894_n1086# nfet_03v3 ad=2.34p pd=9.52u as=2.34p ps=9.52u w=9u l=1.2u
X8 a_n740_n900# a_n980_n992# a_n1084_n900# a_n1894_n1086# nfet_03v3 ad=2.34p pd=9.52u as=2.34p ps=9.52u w=9u l=1.2u
X9 a_n1084_n900# a_n1324_n992# a_n1428_n900# a_n1894_n1086# nfet_03v3 ad=2.34p pd=9.52u as=2.34p ps=9.52u w=9u l=1.2u
C0 a_980_n900# a_1084_n992# 0.21274f
C1 a_740_n992# a_636_n900# 0.21274f
C2 a_n52_n900# a_52_n992# 0.21274f
C3 a_n52_n900# a_n292_n992# 0.21274f
C4 a_n636_n992# a_n396_n900# 0.21274f
C5 a_396_n992# a_636_n900# 0.21274f
C6 a_52_n992# a_292_n900# 0.21274f
C7 a_396_n992# a_292_n900# 0.21274f
C8 a_n396_n900# a_n740_n900# 0.27776f
C9 a_n396_n900# a_n292_n992# 0.21274f
C10 a_636_n900# a_980_n900# 0.27776f
C11 a_1668_n900# a_1428_n992# 0.21274f
C12 a_292_n900# a_636_n900# 0.27776f
C13 a_n52_n900# a_292_n900# 0.27776f
C14 a_n52_n900# a_n396_n900# 0.27776f
C15 a_1428_n992# a_1324_n900# 0.21274f
C16 a_1324_n900# a_1084_n992# 0.21274f
C17 a_980_n900# a_1324_n900# 0.27776f
C18 a_1668_n900# a_1324_n900# 0.27776f
C19 a_n1668_n992# a_n1324_n992# 0.05997f
C20 a_n1324_n992# a_n980_n992# 0.05997f
C21 a_n636_n992# a_n980_n992# 0.05997f
C22 a_n1324_n992# a_n1084_n900# 0.21274f
C23 a_n1428_n900# a_n1324_n992# 0.21274f
C24 a_n636_n992# a_n740_n900# 0.21274f
C25 a_n1428_n900# a_n1668_n992# 0.21274f
C26 a_n740_n900# a_n980_n992# 0.21274f
C27 a_n636_n992# a_n292_n992# 0.05997f
C28 a_n1668_n992# a_n1756_n900# 0.21274f
C29 a_n980_n992# a_n1084_n900# 0.21274f
C30 a_n740_n900# a_n1084_n900# 0.27776f
C31 a_52_n992# a_n292_n992# 0.05997f
C32 a_n1428_n900# a_n1084_n900# 0.27776f
C33 a_1428_n992# a_1084_n992# 0.05997f
C34 a_740_n992# a_1084_n992# 0.05997f
C35 a_740_n992# a_396_n992# 0.05997f
C36 a_n1428_n900# a_n1756_n900# 0.27776f
C37 a_52_n992# a_396_n992# 0.05997f
C38 a_740_n992# a_980_n900# 0.21274f
C39 a_1668_n900# a_n1894_n1086# 1.43999f
C40 a_1324_n900# a_n1894_n1086# 0.9147f
C41 a_980_n900# a_n1894_n1086# 0.88809f
C42 a_636_n900# a_n1894_n1086# 0.88748f
C43 a_292_n900# a_n1894_n1086# 0.88716f
C44 a_n52_n900# a_n1894_n1086# 0.887f
C45 a_n396_n900# a_n1894_n1086# 0.88716f
C46 a_n740_n900# a_n1894_n1086# 0.88748f
C47 a_n1084_n900# a_n1894_n1086# 0.88809f
C48 a_n1428_n900# a_n1894_n1086# 0.9147f
C49 a_n1756_n900# a_n1894_n1086# 1.43999f
.ends

.subckt nfet_03v3_93L8BL a_n1668_n520# a_n2460_n428# a_n636_n520# a_740_n520# a_2116_n520#
+ a_1772_n520# a_2700_n428# a_52_n520# a_1084_n520# a_n2700_n520# a_2012_n428# a_n2116_n428#
+ a_396_n520# a_n1772_n428# a_n2012_n520# a_980_n428# a_n740_n428# a_n1084_n428# a_2356_n428#
+ a_1428_n520# a_292_n428# a_n52_n428# a_n2356_n520# a_1324_n428# a_n2788_n428# a_n980_n520#
+ a_n1428_n428# a_636_n428# a_n396_n428# a_n1324_n520# a_n292_n520# a_2460_n520# a_1668_n428#
+ a_n2926_n614#
X0 a_n1772_n428# a_n2012_n520# a_n2116_n428# a_n2926_n614# nfet_03v3 ad=1.1128p pd=4.8u as=1.1128p ps=4.8u w=4.28u l=1.2u
X1 a_1668_n428# a_1428_n520# a_1324_n428# a_n2926_n614# nfet_03v3 ad=1.1128p pd=4.8u as=1.1128p ps=4.8u w=4.28u l=1.2u
X2 a_n2116_n428# a_n2356_n520# a_n2460_n428# a_n2926_n614# nfet_03v3 ad=1.1128p pd=4.8u as=1.1128p ps=4.8u w=4.28u l=1.2u
X3 a_n2460_n428# a_n2700_n520# a_n2788_n428# a_n2926_n614# nfet_03v3 ad=1.1128p pd=4.8u as=1.8832p ps=9.44u w=4.28u l=1.2u
X4 a_636_n428# a_396_n520# a_292_n428# a_n2926_n614# nfet_03v3 ad=1.1128p pd=4.8u as=1.1128p ps=4.8u w=4.28u l=1.2u
X5 a_980_n428# a_740_n520# a_636_n428# a_n2926_n614# nfet_03v3 ad=1.1128p pd=4.8u as=1.1128p ps=4.8u w=4.28u l=1.2u
X6 a_1324_n428# a_1084_n520# a_980_n428# a_n2926_n614# nfet_03v3 ad=1.1128p pd=4.8u as=1.1128p ps=4.8u w=4.28u l=1.2u
X7 a_2012_n428# a_1772_n520# a_1668_n428# a_n2926_n614# nfet_03v3 ad=1.1128p pd=4.8u as=1.1128p ps=4.8u w=4.28u l=1.2u
X8 a_n396_n428# a_n636_n520# a_n740_n428# a_n2926_n614# nfet_03v3 ad=1.1128p pd=4.8u as=1.1128p ps=4.8u w=4.28u l=1.2u
X9 a_n740_n428# a_n980_n520# a_n1084_n428# a_n2926_n614# nfet_03v3 ad=1.1128p pd=4.8u as=1.1128p ps=4.8u w=4.28u l=1.2u
X10 a_2356_n428# a_2116_n520# a_2012_n428# a_n2926_n614# nfet_03v3 ad=1.1128p pd=4.8u as=1.1128p ps=4.8u w=4.28u l=1.2u
X11 a_n1084_n428# a_n1324_n520# a_n1428_n428# a_n2926_n614# nfet_03v3 ad=1.1128p pd=4.8u as=1.1128p ps=4.8u w=4.28u l=1.2u
X12 a_n1428_n428# a_n1668_n520# a_n1772_n428# a_n2926_n614# nfet_03v3 ad=1.1128p pd=4.8u as=1.1128p ps=4.8u w=4.28u l=1.2u
X13 a_n52_n428# a_n292_n520# a_n396_n428# a_n2926_n614# nfet_03v3 ad=1.1128p pd=4.8u as=1.1128p ps=4.8u w=4.28u l=1.2u
X14 a_292_n428# a_52_n520# a_n52_n428# a_n2926_n614# nfet_03v3 ad=1.1128p pd=4.8u as=1.1128p ps=4.8u w=4.28u l=1.2u
X15 a_2700_n428# a_2460_n520# a_2356_n428# a_n2926_n614# nfet_03v3 ad=1.8832p pd=9.44u as=1.1128p ps=4.8u w=4.28u l=1.2u
C0 a_n52_n428# a_52_n520# 0.10092f
C1 a_n2700_n520# a_n2788_n428# 0.10092f
C2 a_2700_n428# a_2356_n428# 0.13177f
C3 a_n2356_n520# a_n2460_n428# 0.10092f
C4 a_n2700_n520# a_n2460_n428# 0.10092f
C5 a_n52_n428# a_n292_n520# 0.10092f
C6 a_n1324_n520# a_n980_n520# 0.05997f
C7 a_n2356_n520# a_n2012_n520# 0.05997f
C8 a_n2700_n520# a_n2356_n520# 0.05997f
C9 a_n1084_n428# a_n740_n428# 0.13177f
C10 a_n2012_n520# a_n1668_n520# 0.05997f
C11 a_n396_n428# a_n740_n428# 0.13177f
C12 a_n1324_n520# a_n1668_n520# 0.05997f
C13 a_n1772_n428# a_n2116_n428# 0.13177f
C14 a_n740_n428# a_n636_n520# 0.10092f
C15 a_n1324_n520# a_n1428_n428# 0.10092f
C16 a_n980_n520# a_n740_n428# 0.10092f
C17 a_n1084_n428# a_n980_n520# 0.10092f
C18 a_n1428_n428# a_n1668_n520# 0.10092f
C19 a_n2012_n520# a_n1772_n428# 0.10092f
C20 a_1084_n520# a_980_n428# 0.10092f
C21 a_1324_n428# a_1084_n520# 0.10092f
C22 a_636_n428# a_980_n428# 0.13177f
C23 a_740_n520# a_1084_n520# 0.05997f
C24 a_636_n428# a_396_n520# 0.10092f
C25 a_1428_n520# a_1084_n520# 0.05997f
C26 a_1324_n428# a_980_n428# 0.13177f
C27 a_740_n520# a_636_n428# 0.10092f
C28 a_2012_n428# a_1668_n428# 0.13177f
C29 a_740_n520# a_980_n428# 0.10092f
C30 a_636_n428# a_292_n428# 0.13177f
C31 a_740_n520# a_396_n520# 0.05997f
C32 a_2116_n520# a_2012_n428# 0.10092f
C33 a_n396_n428# a_n636_n520# 0.10092f
C34 a_2012_n428# a_2356_n428# 0.13177f
C35 a_1324_n428# a_1428_n520# 0.10092f
C36 a_1324_n428# a_1668_n428# 0.13177f
C37 a_396_n520# a_292_n428# 0.10092f
C38 a_2116_n520# a_2460_n520# 0.05997f
C39 a_2356_n428# a_2460_n520# 0.10092f
C40 a_1428_n520# a_1668_n428# 0.10092f
C41 a_52_n520# a_396_n520# 0.05997f
C42 a_2116_n520# a_2356_n428# 0.10092f
C43 a_52_n520# a_292_n428# 0.10092f
C44 a_2012_n428# a_1772_n520# 0.10092f
C45 a_n980_n520# a_n636_n520# 0.05997f
C46 a_n1084_n428# a_n1324_n520# 0.10092f
C47 a_n396_n428# a_n292_n520# 0.10092f
C48 a_1428_n520# a_1772_n520# 0.05997f
C49 a_1772_n520# a_1668_n428# 0.10092f
C50 a_n1668_n520# a_n1772_n428# 0.10092f
C51 a_n636_n520# a_n292_n520# 0.05997f
C52 a_2116_n520# a_1772_n520# 0.05997f
C53 a_52_n520# a_n292_n520# 0.05997f
C54 a_n2116_n428# a_n2460_n428# 0.13177f
C55 a_n1428_n428# a_n1772_n428# 0.13177f
C56 a_n2788_n428# a_n2460_n428# 0.13177f
C57 a_n2012_n520# a_n2116_n428# 0.10092f
C58 a_n52_n428# a_n396_n428# 0.13177f
C59 a_n1084_n428# a_n1428_n428# 0.13177f
C60 a_n2356_n520# a_n2116_n428# 0.10092f
C61 a_2700_n428# a_2460_n520# 0.10092f
C62 a_n52_n428# a_292_n428# 0.13177f
C63 a_2700_n428# a_n2926_n614# 0.934f
C64 a_2356_n428# a_n2926_n614# 0.90026f
C65 a_2012_n428# a_n2926_n614# 0.87365f
C66 a_1668_n428# a_n2926_n614# 0.87304f
C67 a_1324_n428# a_n2926_n614# 0.87272f
C68 a_980_n428# a_n2926_n614# 0.87253f
C69 a_636_n428# a_n2926_n614# 0.87249f
C70 a_292_n428# a_n2926_n614# 0.87249f
C71 a_n52_n428# a_n2926_n614# 0.87249f
C72 a_n396_n428# a_n2926_n614# 0.87249f
C73 a_n740_n428# a_n2926_n614# 0.87249f
C74 a_n1084_n428# a_n2926_n614# 0.87253f
C75 a_n1428_n428# a_n2926_n614# 0.87272f
C76 a_n1772_n428# a_n2926_n614# 0.87304f
C77 a_n2116_n428# a_n2926_n614# 0.87365f
C78 a_n2460_n428# a_n2926_n614# 0.90026f
C79 a_n2788_n428# a_n2926_n614# 0.934f
.ends

.subckt nfet_03v3_H6E8H4 a_52_n168# a_n152_n168# a_152_n76# a_n240_n76# a_n52_n76#
+ a_n378_n262#
X0 a_n52_n76# a_n152_n168# a_n240_n76# a_n378_n262# nfet_03v3 ad=0.26p pd=1.52u as=0.44p ps=2.88u w=1u l=0.5u
X1 a_152_n76# a_52_n168# a_n52_n76# a_n378_n262# nfet_03v3 ad=0.44p pd=2.88u as=0.26p ps=1.52u w=1u l=0.5u
C0 a_52_n168# a_n152_n168# 0.03518f
C1 a_n152_n168# a_n52_n76# 0.01275f
C2 a_n240_n76# a_n152_n168# 0.01275f
C3 a_52_n168# a_n52_n76# 0.01275f
C4 a_152_n76# a_52_n168# 0.01275f
C5 a_n240_n76# a_n52_n76# 0.05767f
C6 a_152_n76# a_n52_n76# 0.05767f
C7 a_152_n76# a_n378_n262# 0.21769f
C8 a_n52_n76# a_n378_n262# 0.20999f
C9 a_n240_n76# a_n378_n262# 0.21769f
.ends

.subckt nfet_03v3_5FAP53 a_52_n168# a_n152_n168# a_152_n76# a_n240_n76# a_n52_n76#
+ VSUBS
X0 a_n52_n76# a_n152_n168# a_n240_n76# VSUBS nfet_03v3 ad=0.26p pd=1.52u as=0.44p ps=2.88u w=1u l=0.5u
X1 a_152_n76# a_52_n168# a_n52_n76# VSUBS nfet_03v3 ad=0.44p pd=2.88u as=0.26p ps=1.52u w=1u l=0.5u
C0 a_52_n168# a_n152_n168# 0.03518f
C1 a_n152_n168# a_n52_n76# 0.01275f
C2 a_n240_n76# a_n152_n168# 0.01275f
C3 a_52_n168# a_n52_n76# 0.01275f
C4 a_152_n76# a_52_n168# 0.01275f
C5 a_n240_n76# a_n52_n76# 0.05767f
C6 a_152_n76# a_n52_n76# 0.05767f
C7 a_152_n76# VSUBS 0.14655f
C8 a_n52_n76# VSUBS 0.19961f
C9 a_n240_n76# VSUBS 0.14655f
.ends

.subckt pfet_03v3_KDKZ8D a_1668_n1636# a_980_n1636# a_n1084_n1636# a_740_24# a_n1324_24#
+ a_n396_n1636# a_n740_n1636# a_52_n1728# a_n980_24# a_52_24# a_396_24# a_n636_24#
+ a_n396_116# a_1428_24# a_1428_n1728# a_n1324_n1728# a_n1084_116# a_740_n1728# a_396_n1728#
+ a_n636_n1728# a_292_116# a_n1668_24# w_n1918_n1846# a_1084_n1728# a_n292_n1728#
+ a_980_116# a_n740_116# a_n52_116# a_636_n1636# a_n52_n1636# a_n1668_n1728# a_1324_n1636#
+ a_1668_116# a_n1756_116# a_292_n1636# a_n980_n1728# a_n1428_116# a_n292_24# a_636_116#
+ a_n1428_n1636# a_1324_116# a_1084_24# a_n1756_n1636# VSUBS
X0 a_1668_n1636# a_1428_n1728# a_1324_n1636# w_n1918_n1846# pfet_03v3 ad=3.344p pd=16.08u as=1.976p ps=8.12u w=7.6u l=1.2u
X1 a_1324_116# a_1084_24# a_980_116# w_n1918_n1846# pfet_03v3 ad=1.976p pd=8.12u as=1.976p ps=8.12u w=7.6u l=1.2u
X2 a_636_n1636# a_396_n1728# a_292_n1636# w_n1918_n1846# pfet_03v3 ad=1.976p pd=8.12u as=1.976p ps=8.12u w=7.6u l=1.2u
X3 a_1668_116# a_1428_24# a_1324_116# w_n1918_n1846# pfet_03v3 ad=3.344p pd=16.08u as=1.976p ps=8.12u w=7.6u l=1.2u
X4 a_n740_n1636# a_n980_n1728# a_n1084_n1636# w_n1918_n1846# pfet_03v3 ad=1.976p pd=8.12u as=1.976p ps=8.12u w=7.6u l=1.2u
X5 a_1324_n1636# a_1084_n1728# a_980_n1636# w_n1918_n1846# pfet_03v3 ad=1.976p pd=8.12u as=1.976p ps=8.12u w=7.6u l=1.2u
X6 a_636_116# a_396_24# a_292_116# w_n1918_n1846# pfet_03v3 ad=1.976p pd=8.12u as=1.976p ps=8.12u w=7.6u l=1.2u
X7 a_980_116# a_740_24# a_636_116# w_n1918_n1846# pfet_03v3 ad=1.976p pd=8.12u as=1.976p ps=8.12u w=7.6u l=1.2u
X8 a_n1428_116# a_n1668_24# a_n1756_116# w_n1918_n1846# pfet_03v3 ad=1.976p pd=8.12u as=3.344p ps=16.08u w=7.6u l=1.2u
X9 a_n1428_n1636# a_n1668_n1728# a_n1756_n1636# w_n1918_n1846# pfet_03v3 ad=1.976p pd=8.12u as=3.344p ps=16.08u w=7.6u l=1.2u
X10 a_n1084_116# a_n1324_24# a_n1428_116# w_n1918_n1846# pfet_03v3 ad=1.976p pd=8.12u as=1.976p ps=8.12u w=7.6u l=1.2u
X11 a_n740_116# a_n980_24# a_n1084_116# w_n1918_n1846# pfet_03v3 ad=1.976p pd=8.12u as=1.976p ps=8.12u w=7.6u l=1.2u
X12 a_n396_n1636# a_n636_n1728# a_n740_n1636# w_n1918_n1846# pfet_03v3 ad=1.976p pd=8.12u as=1.976p ps=8.12u w=7.6u l=1.2u
X13 a_n52_116# a_n292_24# a_n396_116# w_n1918_n1846# pfet_03v3 ad=1.976p pd=8.12u as=1.976p ps=8.12u w=7.6u l=1.2u
X14 a_n52_n1636# a_n292_n1728# a_n396_n1636# w_n1918_n1846# pfet_03v3 ad=1.976p pd=8.12u as=1.976p ps=8.12u w=7.6u l=1.2u
X15 a_n396_116# a_n636_24# a_n740_116# w_n1918_n1846# pfet_03v3 ad=1.976p pd=8.12u as=1.976p ps=8.12u w=7.6u l=1.2u
X16 a_292_116# a_52_24# a_n52_116# w_n1918_n1846# pfet_03v3 ad=1.976p pd=8.12u as=1.976p ps=8.12u w=7.6u l=1.2u
X17 a_n1084_n1636# a_n1324_n1728# a_n1428_n1636# w_n1918_n1846# pfet_03v3 ad=1.976p pd=8.12u as=1.976p ps=8.12u w=7.6u l=1.2u
X18 a_980_n1636# a_740_n1728# a_636_n1636# w_n1918_n1846# pfet_03v3 ad=1.976p pd=8.12u as=1.976p ps=8.12u w=7.6u l=1.2u
X19 a_292_n1636# a_52_n1728# a_n52_n1636# w_n1918_n1846# pfet_03v3 ad=1.976p pd=8.12u as=1.976p ps=8.12u w=7.6u l=1.2u
C0 a_n740_116# a_n980_24# 0.17958f
C1 a_n636_24# a_n636_n1728# 0.22367f
C2 w_n1918_n1846# a_1668_n1636# 0.97617f
C3 a_n1084_116# a_n1084_n1636# 0.0083f
C4 a_n636_24# a_n396_116# 0.17958f
C5 a_n636_24# a_n740_116# 0.17958f
C6 w_n1918_n1846# a_740_n1728# 0.57685f
C7 a_1324_n1636# w_n1918_n1846# 0.29848f
C8 a_1084_24# a_1084_n1728# 0.22367f
C9 a_1428_24# a_1428_n1728# 0.22367f
C10 a_n1324_n1728# a_n1084_n1636# 0.17958f
C11 a_n1756_n1636# a_n1756_116# 0.0083f
C12 w_n1918_n1846# a_n1084_n1636# 0.29845f
C13 a_396_n1728# w_n1918_n1846# 0.57655f
C14 a_n1756_n1636# w_n1918_n1846# 0.97617f
C15 w_n1918_n1846# a_1084_n1728# 0.57774f
C16 a_292_n1636# w_n1918_n1846# 0.29843f
C17 a_n1428_116# a_n1428_n1636# 0.0083f
C18 w_n1918_n1846# a_n52_n1636# 0.29842f
C19 a_n1324_n1728# a_n1428_n1636# 0.17958f
C20 a_n396_n1636# w_n1918_n1846# 0.29843f
C21 w_n1918_n1846# a_n740_n1636# 0.29843f
C22 w_n1918_n1846# a_n1428_n1636# 0.29848f
C23 a_n1324_n1728# a_n1668_n1728# 0.05997f
C24 w_n1918_n1846# a_1428_n1728# 0.61972f
C25 w_n1918_n1846# a_n1668_n1728# 0.61972f
C26 w_n1918_n1846# a_52_24# 0.57623f
C27 a_1084_24# a_740_24# 0.05997f
C28 a_n1668_24# a_n1668_n1728# 0.22367f
C29 a_1084_24# a_1428_24# 0.05997f
C30 a_n1084_116# a_n1428_116# 0.23446f
C31 a_52_24# a_n292_24# 0.05997f
C32 w_n1918_n1846# a_740_24# 0.57685f
C33 a_n1084_116# w_n1918_n1846# 0.29845f
C34 w_n1918_n1846# a_1428_24# 0.61972f
C35 a_1084_24# w_n1918_n1846# 0.57774f
C36 a_n1428_116# a_n1756_116# 0.23446f
C37 a_n1084_116# a_n980_24# 0.17958f
C38 w_n1918_n1846# a_n1428_116# 0.29848f
C39 a_n1324_n1728# w_n1918_n1846# 0.57774f
C40 a_n1084_116# a_n1324_24# 0.17958f
C41 w_n1918_n1846# a_n1756_116# 0.97617f
C42 a_n1668_24# a_n1428_116# 0.17958f
C43 a_n1668_24# a_n1756_116# 0.17958f
C44 w_n1918_n1846# a_n292_24# 0.57623f
C45 a_n1668_24# w_n1918_n1846# 0.61972f
C46 a_n1324_24# a_n1428_116# 0.17958f
C47 a_n1324_n1728# a_n1324_24# 0.22367f
C48 w_n1918_n1846# a_n980_24# 0.57685f
C49 a_n1324_24# w_n1918_n1846# 0.57774f
C50 a_n636_24# w_n1918_n1846# 0.57655f
C51 a_n1668_24# a_n1324_24# 0.05997f
C52 a_n636_24# a_n292_24# 0.05997f
C53 a_n1324_24# a_n980_24# 0.05997f
C54 a_n636_24# a_n980_24# 0.05997f
C55 a_980_n1636# a_980_116# 0.0083f
C56 a_636_n1636# a_980_n1636# 0.23446f
C57 a_396_24# a_636_116# 0.17958f
C58 a_396_24# a_292_116# 0.17958f
C59 a_980_n1636# a_740_n1728# 0.17958f
C60 a_1324_n1636# a_980_n1636# 0.23446f
C61 a_1324_116# a_980_116# 0.23446f
C62 a_1324_116# a_1668_116# 0.23446f
C63 a_636_116# a_980_116# 0.23446f
C64 a_636_116# a_292_116# 0.23446f
C65 a_n292_n1728# a_52_n1728# 0.05997f
C66 a_n52_116# a_292_116# 0.23446f
C67 a_636_n1636# a_636_116# 0.0083f
C68 a_980_n1636# a_1084_n1728# 0.17958f
C69 a_n292_n1728# a_n636_n1728# 0.05997f
C70 a_n396_116# a_n52_116# 0.23446f
C71 a_n980_n1728# a_n636_n1728# 0.05997f
C72 a_n396_116# a_n740_116# 0.23446f
C73 a_396_n1728# a_396_24# 0.22367f
C74 a_1668_116# a_1668_n1636# 0.0083f
C75 a_1324_n1636# a_1324_116# 0.0083f
C76 a_636_n1636# a_740_n1728# 0.17958f
C77 a_52_24# a_396_24# 0.05997f
C78 a_396_n1728# a_52_n1728# 0.05997f
C79 a_292_n1636# a_52_n1728# 0.17958f
C80 a_52_n1728# a_n52_n1636# 0.17958f
C81 a_292_n1636# a_292_116# 0.0083f
C82 a_n980_n1728# a_n1084_n1636# 0.17958f
C83 a_396_n1728# a_636_n1636# 0.17958f
C84 a_n52_n1636# a_n52_116# 0.0083f
C85 a_292_n1636# a_636_n1636# 0.23446f
C86 a_n396_n1636# a_n292_n1728# 0.17958f
C87 a_n292_n1728# a_n52_n1636# 0.17958f
C88 a_n396_n1636# a_n636_n1728# 0.17958f
C89 a_n396_n1636# a_n396_116# 0.0083f
C90 a_740_24# a_396_24# 0.05997f
C91 a_n740_n1636# a_n980_n1728# 0.17958f
C92 a_n740_n1636# a_n636_n1728# 0.17958f
C93 a_1324_n1636# a_1668_n1636# 0.23446f
C94 a_n740_116# a_n740_n1636# 0.0083f
C95 w_n1918_n1846# a_980_n1636# 0.29845f
C96 a_52_n1728# a_52_24# 0.22367f
C97 a_52_24# a_292_116# 0.17958f
C98 a_52_24# a_n52_116# 0.17958f
C99 a_396_n1728# a_740_n1728# 0.05997f
C100 a_740_n1728# a_1084_n1728# 0.05997f
C101 w_n1918_n1846# a_396_24# 0.57655f
C102 a_1428_n1728# a_1668_n1636# 0.17958f
C103 a_1324_n1636# a_1084_n1728# 0.17958f
C104 a_740_24# a_980_116# 0.17958f
C105 a_740_24# a_636_116# 0.17958f
C106 a_1324_116# a_1428_24# 0.17958f
C107 a_1324_n1636# a_1428_n1728# 0.17958f
C108 a_1428_24# a_1668_116# 0.17958f
C109 a_1324_116# a_1084_24# 0.17958f
C110 a_n1084_116# a_n740_116# 0.23446f
C111 a_1084_24# a_980_116# 0.17958f
C112 a_396_n1728# a_292_n1636# 0.17958f
C113 a_292_n1636# a_n52_n1636# 0.23446f
C114 a_n740_n1636# a_n1084_n1636# 0.23446f
C115 a_n396_n1636# a_n52_n1636# 0.23446f
C116 a_n1084_n1636# a_n1428_n1636# 0.23446f
C117 a_n1756_n1636# a_n1428_n1636# 0.23446f
C118 a_52_n1728# w_n1918_n1846# 0.57623f
C119 a_1324_116# w_n1918_n1846# 0.29848f
C120 a_1428_n1728# a_1084_n1728# 0.05997f
C121 a_n396_n1636# a_n740_n1636# 0.23446f
C122 w_n1918_n1846# a_980_116# 0.29845f
C123 w_n1918_n1846# a_1668_116# 0.97617f
C124 w_n1918_n1846# a_636_116# 0.29843f
C125 a_n1324_n1728# a_n980_n1728# 0.05997f
C126 w_n1918_n1846# a_292_116# 0.29843f
C127 a_n1756_n1636# a_n1668_n1728# 0.17958f
C128 a_n292_n1728# w_n1918_n1846# 0.57623f
C129 w_n1918_n1846# a_n52_116# 0.29842f
C130 w_n1918_n1846# a_n980_n1728# 0.57685f
C131 w_n1918_n1846# a_n636_n1728# 0.57655f
C132 a_636_n1636# w_n1918_n1846# 0.29843f
C133 a_n396_116# w_n1918_n1846# 0.29843f
C134 w_n1918_n1846# a_n740_116# 0.29843f
C135 a_740_24# a_740_n1728# 0.22367f
C136 a_n1668_n1728# a_n1428_n1636# 0.17958f
C137 a_n292_24# a_n52_116# 0.17958f
C138 a_n292_n1728# a_n292_24# 0.22367f
C139 a_n396_116# a_n292_24# 0.17958f
C140 a_n980_24# a_n980_n1728# 0.22367f
C141 a_1668_n1636# VSUBS 0.01781f
C142 a_1324_n1636# VSUBS 0.03047f
C143 a_980_n1636# VSUBS 0.02532f
C144 a_636_n1636# VSUBS 0.02532f
C145 a_292_n1636# VSUBS 0.02532f
C146 a_n52_n1636# VSUBS 0.02532f
C147 a_n396_n1636# VSUBS 0.02532f
C148 a_n740_n1636# VSUBS 0.02532f
C149 a_n1084_n1636# VSUBS 0.02532f
C150 a_n1428_n1636# VSUBS 0.03047f
C151 a_n1756_n1636# VSUBS 0.01781f
C152 a_1668_116# VSUBS 0.01781f
C153 a_1324_116# VSUBS 0.03047f
C154 a_980_116# VSUBS 0.02532f
C155 a_636_116# VSUBS 0.02532f
C156 a_292_116# VSUBS 0.02532f
C157 a_n52_116# VSUBS 0.02532f
C158 a_n396_116# VSUBS 0.02532f
C159 a_n740_116# VSUBS 0.02532f
C160 a_n1084_116# VSUBS 0.02532f
C161 a_n1428_116# VSUBS 0.03047f
C162 a_n1756_116# VSUBS 0.01781f
C163 w_n1918_n1846# VSUBS 44.8488f
.ends

.subckt comparator_3v3_VSS VDDH Vip Vin VBN1 VSS VBP1 OUT
XXM12 VSS net7 net7 VSS VSS net7 net7 VSS net7 net7 VSS net7 net7 net7 nfet_03v3_YWK8CE
XXM13 vwp VDDH vwp vwp vwp VDDH vxn vwp VDDH VDDH vwp vxn vwp vxn vxn VDDH vwp vxn
+ vwp VDDH VDDH vwp VSS pfet_03v3_LN29N7
XXM14 VBP1 net4 net4 VBP1 VBP1 VBP1 VDDH VBP1 VBP1 VBP1 VBP1 VBP1 net4 net4 VDDH net4
+ VDDH net4 VBP1 VBP1 VBP1 VBP1 VBP1 VBP1 VDDH VDDH VDDH net4 VBP1 VBP1 VBP1 VBP1
+ VBP1 VBP1 net4 VBP1 VDDH VDDH VBP1 VDDH VDDH VBP1 VDDH VDDH VBP1 VDDH VBP1 net4
+ VBP1 net4 VBP1 VBP1 VBP1 VBP1 VBP1 VBP1 net4 VBP1 net4 VDDH VBP1 net4 VBP1 VBP1
+ VDDH net4 VBP1 VDDH VDDH net4 net4 net4 net4 net4 net4 VBP1 net4 VDDH VBP1 VDDH
+ net4 VBP1 VBP1 VBP1 net4 VBP1 VBP1 VBP1 VBP1 VBP1 VDDH net4 VBP1 VDDH VDDH VDDH
+ VBP1 VDDH VBP1 VDDH net4 net4 VDDH net4 net4 VDDH VDDH net4 VBP1 VBP1 VBP1 VBP1
+ VBP1 VDDH VBP1 VDDH VDDH net4 VBP1 VDDH VBP1 VDDH net4 VBP1 VBP1 VBP1 VBP1 net4
+ VBP1 VDDH VDDH VDDH VDDH VSS pfet_03v3_UB86XQ
XXM25 VSS VSS VSS net8 net9 net8 net9 net9 net8 net8 net9 VSS VSS net8 VSS net8 net8
+ net8 nfet_03v3_TNDTXF
XXM24 net8 net9 net9 net9 net8 net8 VDDH net8 net8 VDDH VDDH net8 net8 VDDH VDDH net8
+ VDDH VDDH net9 net8 net9 net8 VSS pfet_03v3_BXNJAZ
XXM26 net9 OUT OUT OUT net9 net9 VDDH net9 net9 VDDH VDDH net9 net9 VDDH VDDH net9
+ VDDH VDDH OUT net9 OUT net9 VSS pfet_03v3_BXNJAZ
XXM16 VSS VSS vxn VSS vxn vxn VSS vxn vxn vxn nfet_03v3_C4MKPC
XXM27 VSS VSS vxp VSS vxp vxp VSS vxp vxp vxp nfet_03v3_C4MKPC
XXM28 VSS VSS VSS net9 OUT net9 OUT OUT net9 net9 OUT VSS VSS net9 VSS net9 net9 net9
+ nfet_03v3_TNDTXF
XXM17 net4 Vip Vip Vip net2 net4 net4 Vip net4 net4 Vip net4 net2 Vip Vip Vip net4
+ Vip net4 net4 Vip net4 net2 Vip Vip net2 Vip Vip Vip VDDH Vip net4 net4 Vip net2
+ Vip net2 Vip net2 net2 net2 Vip net2 VSS pfet_03v3_6BU64J
XXM29 VDDH VWN VWN VWN VWN VWN VDDH VWN VWN VWN VWN VDDH VWN VWN VDDH VDDH VDDH VWN
+ VSS pfet_03v3_NRUA5E
XXM19 VSS net2 net2 VSS VSS net2 vwp VSS net2 vwp VSS net2 vwp net2 nfet_03v3_YWK8CE
XXM1 VDDH vwp vwp vwp vwp vwp VDDH vwp vwp vwp vwp VDDH vwp vwp VDDH VDDH VDDH vwp
+ VSS pfet_03v3_NRUA5E
XXM2 Vip Vip Vip Vip VSS VWN net1 Vip VWN VWN Vip net1 Vip net1 net1 VWN Vip net1
+ Vip VWN VWN Vip nfet_03v3_ZTT4MX
Xnfet_03v3_TNDTXF_0 VSS VSS VSS net5 net8 net5 net8 net8 net5 net5 net8 VSS VSS net5
+ VSS net5 net5 net5 nfet_03v3_TNDTXF
XXM3 VWN VDDH VWN VWN VWN VDDH vxp VWN VDDH VDDH VWN vxp VWN vxp vxp VDDH VWN vxp
+ VWN VDDH VDDH VWN VSS pfet_03v3_LN29N7
XXM4 Vin Vin Vin Vin VSS vwp net1 Vin vwp vwp Vin net1 Vin net1 net1 vwp Vin net1
+ Vin vwp vwp Vin nfet_03v3_ZTT4MX
XXM5 VSS net2 net2 VSS VSS net2 net2 VSS net2 net2 VSS net2 net2 net2 nfet_03v3_YWK8CE
XXM6 VBN1 net1 VBN1 VBN1 VBN1 VBN1 VSS VBN1 VBN1 VBN1 VSS VSS VBN1 net1 VBN1 net1
+ VSS net1 net1 VBN1 net1 VSS VBN1 VSS VSS VBN1 VSS VSS net1 VBN1 VBN1 VBN1 net1 VSS
+ nfet_03v3_93L8BL
XXM7 VBP1 net6 net6 VBP1 VBP1 VBP1 VDDH VBP1 VBP1 VBP1 VBP1 VBP1 net6 net6 VDDH net6
+ VDDH net6 VBP1 VBP1 VBP1 VBP1 VBP1 VBP1 VDDH VDDH VDDH net6 VBP1 VBP1 VBP1 VBP1
+ VBP1 VBP1 net6 VBP1 VDDH VDDH VBP1 VDDH VDDH VBP1 VDDH VDDH VBP1 VDDH VBP1 net6
+ VBP1 net6 VBP1 VBP1 VBP1 VBP1 VBP1 VBP1 net6 VBP1 net6 VDDH VBP1 net6 VBP1 VBP1
+ VDDH net6 VBP1 VDDH VDDH net6 net6 net6 net6 net6 net6 VBP1 net6 VDDH VBP1 VDDH
+ net6 VBP1 VBP1 VBP1 net6 VBP1 VBP1 VBP1 VBP1 VBP1 VDDH net6 VBP1 VDDH VDDH VDDH
+ VBP1 VDDH VBP1 VDDH net6 net6 VDDH net6 net6 VDDH VDDH net6 VBP1 VBP1 VBP1 VBP1
+ VBP1 VDDH VBP1 VDDH VDDH net6 VBP1 VDDH VBP1 VDDH net6 VBP1 VBP1 VBP1 VBP1 net6
+ VBP1 VDDH VDDH VDDH VDDH VSS pfet_03v3_UB86XQ
XXM8 VSS net3 net3 VSS VSS net3 VWN VSS net3 VWN VSS net3 VWN net3 nfet_03v3_YWK8CE
XXM9 net4 Vin Vin Vin net3 net4 net4 Vin net4 net4 Vin net4 net3 Vin Vin Vin net4
+ Vin net4 net4 Vin net4 net3 Vin Vin net3 Vin Vin Vin VDDH Vin net4 net4 Vin net3
+ Vin net3 Vin net3 net3 net3 Vin net3 VSS pfet_03v3_6BU64J
Xnfet_03v3_H6E8H4_0 vxp vxp VSS VSS vxn VSS nfet_03v3_H6E8H4
Xnfet_03v3_5FAP53_0 vxn vxn VSS VSS vxp VSS nfet_03v3_5FAP53
XXM20 net6 net6 net6 vxp vxp net6 net5 vxp vxp vxp vxp vxp net6 vxp vxp vxp net6 vxp
+ vxp vxp net6 vxp VDDH vxp vxp net6 net5 net5 net5 net5 vxp net5 net6 net6 net6 vxp
+ net5 vxp net5 net5 net5 vxp net6 VSS pfet_03v3_KDKZ8D
XXM21 net5 net8 net8 net8 net5 net5 VDDH net5 net5 VDDH VDDH net5 net5 VDDH VDDH net5
+ VDDH VDDH net8 net5 net8 net5 VSS pfet_03v3_BXNJAZ
XXM10 net6 net6 net6 vxn vxn net6 net7 vxn vxn vxn vxn vxn net6 vxn vxn vxn net6 vxn
+ vxn vxn net6 vxn VDDH vxn vxn net6 net7 net7 net7 net7 vxn net7 net6 net6 net6 vxn
+ net7 vxn net7 net7 net7 vxn net6 VSS pfet_03v3_KDKZ8D
XXM22 VSS net7 net7 VSS VSS net7 net5 VSS net7 net5 VSS net7 net5 net7 nfet_03v3_YWK8CE
XXM11 VSS net3 net3 VSS VSS net3 net3 VSS net3 net3 VSS net3 net3 net3 nfet_03v3_YWK8CE
C0 VDDH net9 1.52021f
C1 Vin VBN1 0.0577f
C2 vxp net7 0.08753f
C3 vxn net7 1.99027f
C4 VDDH VBN1 0.62917f
C5 VWN VBN1 0.07257f
C6 Vin vxp 0.15285f
C7 net6 net7 2.75634f
C8 Vin vxn 0.53232f
C9 Vin Vip 0.011f
C10 Vin net1 1.43978f
C11 VDDH vxp 3.19186f
C12 VDDH vxn 2.6934f
C13 VWN vxp 1.69493f
C14 VWN vxn 0
C15 VDDH Vip 4.51576f
C16 VDDH net1 0.71373f
C17 VWN Vip 1.02888f
C18 VWN net1 1.32278f
C19 net9 OUT 0.62232f
C20 VDDH net6 9.26535f
C21 VDDH net7 0.26881f
C22 VDDH Vin 2.45112f
C23 Vin VWN 0.19062f
C24 net8 net5 0.68833f
C25 VDDH VWN 6.84132f
C26 vwp net3 0.01959f
C27 vwp net2 0.30522f
C28 net8 net9 0.7157f
C29 VDDH OUT 0.67555f
C30 vwp VBP1 0.15025f
C31 net2 net3 0.04379f
C32 net3 VBP1 0.00121f
C33 vwp net4 1.22403f
C34 net2 VBP1 0
C35 net3 net4 3.21225f
C36 net2 net4 3.12479f
C37 net4 VBP1 4.41516f
C38 VDDH net8 1.51174f
C39 vwp VBN1 0
C40 VBP1 net5 0
C41 vwp vxp 0.16988f
C42 vwp vxn 1.2026f
C43 vwp Vip 0.44825f
C44 vwp net1 1.72877f
C45 net8 OUT 0.0018f
C46 net3 Vip 0.0139f
C47 VBP1 VBN1 1.2136f
C48 net2 Vip 1.87403f
C49 VBP1 vxp 0.0696f
C50 vxn VBP1 0.33749f
C51 vwp Vin 1.74313f
C52 net3 net7 0.00137f
C53 VBP1 Vip 0.34649f
C54 VBP1 net1 0.00108f
C55 net9 net5 0.00132f
C56 net4 VBN1 0.00444f
C57 vwp VDDH 11.39733f
C58 vwp VWN 1.90838f
C59 net6 VBP1 4.27717f
C60 net3 Vin 1.86595f
C61 VBP1 net7 0
C62 net3 VDDH 0.28399f
C63 net2 Vin 0.0175f
C64 net3 VWN 0.36586f
C65 net4 Vip 2.27893f
C66 net4 net1 0
C67 vxp net5 2.04466f
C68 net2 VDDH 0.3717f
C69 vxn net5 0.0056f
C70 net2 VWN 0.164f
C71 Vin VBP1 0.25264f
C72 VDDH VBP1 19.05761f
C73 VWN VBP1 1.22778f
C74 net6 net5 2.7404f
C75 net5 net7 0.31457f
C76 Vin net4 2.17266f
C77 VDDH net4 10.95506f
C78 VWN net4 0.00356f
C79 Vip VBN1 1.7769f
C80 net1 VBN1 1.09504f
C81 VDDH net5 1.02766f
C82 vxn vxp 1.56568f
C83 net1 Vip 1.30413f
C84 net6 vxp 2.33233f
C85 vxn net6 2.61775f
C86 VBN1 VSS 3.03657f
C87 vxn VSS 3.6844f
C88 VBP1 VSS 13.06068f
C89 net3 VSS 2.77908f
C90 net7 VSS 3.70673f
C91 net6 VSS 1.78133f
C92 net5 VSS 2.87073f
C93 vxp VSS 4.40267f
C94 Vin VSS 8.55393f
C95 VDDH VSS 2.69814f
C96 VWN VSS 9.16946f
C97 net1 VSS 4.13965f
C98 net8 VSS 1.60711f
C99 vwp VSS 8.71502f
C100 net2 VSS 2.80849f
C101 net4 VSS 1.51166f
C102 Vip VSS 1.46797f
C103 OUT VSS 1.27635f
C104 net9 VSS 1.60946f
.ends
