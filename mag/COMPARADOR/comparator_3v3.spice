* NGSPICE file created from comparator_3v3.ext - technology: gf180mcuD

.subckt nfet_03v3_YWK8CE a_n1068_n217# a_52_n309# a_396_n309# a_n1206_n403# a_980_n217#
+ a_n980_n309# a_n740_n217# a_292_n217# a_n292_n309# a_n52_n217# a_n396_n217# a_n636_n309#
+ a_636_n217# a_740_n309#
X0 a_n396_n217# a_n636_n309# a_n740_n217# a_n1206_n403# nfet_03v3 ad=0.5642p pd=2.69u as=0.5642p ps=2.69u w=2.17u l=1.2u
X1 a_n740_n217# a_n980_n309# a_n1068_n217# a_n1206_n403# nfet_03v3 ad=0.5642p pd=2.69u as=0.9548p ps=5.22u w=2.17u l=1.2u
X2 a_n52_n217# a_n292_n309# a_n396_n217# a_n1206_n403# nfet_03v3 ad=0.5642p pd=2.69u as=0.5642p ps=2.69u w=2.17u l=1.2u
X3 a_292_n217# a_52_n309# a_n52_n217# a_n1206_n403# nfet_03v3 ad=0.5642p pd=2.69u as=0.5642p ps=2.69u w=2.17u l=1.2u
X4 a_636_n217# a_396_n309# a_292_n217# a_n1206_n403# nfet_03v3 ad=0.5642p pd=2.69u as=0.5642p ps=2.69u w=2.17u l=1.2u
X5 a_980_n217# a_740_n309# a_636_n217# a_n1206_n403# nfet_03v3 ad=0.9548p pd=5.22u as=0.5642p ps=2.69u w=2.17u l=1.2u
C0 a_636_n217# a_980_n217# 0.0665f
C1 a_636_n217# a_396_n309# 0.05094f
C2 a_n740_n217# a_n1068_n217# 0.0665f
C3 a_n740_n217# a_n636_n309# 0.05094f
C4 a_292_n217# a_396_n309# 0.05094f
C5 a_n396_n217# a_n636_n309# 0.05094f
C6 a_n636_n309# a_n292_n309# 0.05997f
C7 a_n52_n217# a_n396_n217# 0.0665f
C8 a_n52_n217# a_n292_n309# 0.05094f
C9 a_636_n217# a_740_n309# 0.05094f
C10 a_n740_n217# a_n396_n217# 0.0665f
C11 a_980_n217# a_740_n309# 0.05094f
C12 a_740_n309# a_396_n309# 0.05997f
C13 a_n52_n217# a_52_n309# 0.05094f
C14 a_n1068_n217# a_n980_n309# 0.05094f
C15 a_n396_n217# a_n292_n309# 0.05094f
C16 a_n636_n309# a_n980_n309# 0.05997f
C17 a_292_n217# a_52_n309# 0.05094f
C18 a_52_n309# a_396_n309# 0.05997f
C19 a_n740_n217# a_n980_n309# 0.05094f
C20 a_52_n309# a_n292_n309# 0.05997f
C21 a_n52_n217# a_292_n217# 0.0665f
C22 a_292_n217# a_636_n217# 0.0665f
C23 a_980_n217# a_n1206_n403# 0.70875f
C24 a_636_n217# a_n1206_n403# 0.89684f
C25 a_292_n217# a_n1206_n403# 0.87043f
C26 a_n52_n217# a_n1206_n403# 0.87013f
C27 a_n396_n217# a_n1206_n403# 0.87043f
C28 a_n740_n217# a_n1206_n403# 0.89684f
C29 a_n1068_n217# a_n1206_n403# 0.70875f
.ends

.subckt pfet_03v3_LN29N7 a_1428_n992# w_n1918_n1110# a_n980_n992# a_n1324_n992# a_n292_n992#
+ a_980_n900# a_n740_n900# a_n1668_n992# a_n1084_n900# a_292_n900# a_n636_n992# a_n52_n900#
+ a_740_n992# a_1324_n900# a_n1428_n900# a_n396_n900# a_52_n992# a_636_n900# a_1084_n992#
+ a_1668_n900# a_n1756_n900# a_396_n992# VSUBS
X0 a_n1084_n900# a_n1324_n992# a_n1428_n900# w_n1918_n1110# pfet_03v3 ad=2.34p pd=9.52u as=2.34p ps=9.52u w=9u l=1.2u
X1 a_n52_n900# a_n292_n992# a_n396_n900# w_n1918_n1110# pfet_03v3 ad=2.34p pd=9.52u as=2.34p ps=9.52u w=9u l=1.2u
X2 a_n1428_n900# a_n1668_n992# a_n1756_n900# w_n1918_n1110# pfet_03v3 ad=2.34p pd=9.52u as=3.96p ps=18.88u w=9u l=1.2u
X3 a_292_n900# a_52_n992# a_n52_n900# w_n1918_n1110# pfet_03v3 ad=2.34p pd=9.52u as=2.34p ps=9.52u w=9u l=1.2u
X4 a_1668_n900# a_1428_n992# a_1324_n900# w_n1918_n1110# pfet_03v3 ad=3.96p pd=18.88u as=2.34p ps=9.52u w=9u l=1.2u
X5 a_636_n900# a_396_n992# a_292_n900# w_n1918_n1110# pfet_03v3 ad=2.34p pd=9.52u as=2.34p ps=9.52u w=9u l=1.2u
X6 a_980_n900# a_740_n992# a_636_n900# w_n1918_n1110# pfet_03v3 ad=2.34p pd=9.52u as=2.34p ps=9.52u w=9u l=1.2u
X7 a_1324_n900# a_1084_n992# a_980_n900# w_n1918_n1110# pfet_03v3 ad=2.34p pd=9.52u as=2.34p ps=9.52u w=9u l=1.2u
X8 a_n396_n900# a_n636_n992# a_n740_n900# w_n1918_n1110# pfet_03v3 ad=2.34p pd=9.52u as=2.34p ps=9.52u w=9u l=1.2u
X9 a_n740_n900# a_n980_n992# a_n1084_n900# w_n1918_n1110# pfet_03v3 ad=2.34p pd=9.52u as=2.34p ps=9.52u w=9u l=1.2u
C0 a_n636_n992# a_n292_n992# 0.05997f
C1 a_1324_n900# a_1428_n992# 0.21274f
C2 a_636_n900# w_n1918_n1110# 0.37123f
C3 a_292_n900# a_636_n900# 0.27776f
C4 a_n1756_n900# w_n1918_n1110# 1.17199f
C5 a_1668_n900# a_1428_n992# 0.21274f
C6 a_n1324_n992# w_n1918_n1110# 0.85112f
C7 a_n1428_n900# a_n1084_n900# 0.27776f
C8 a_980_n900# w_n1918_n1110# 0.37124f
C9 a_n636_n992# w_n1918_n1110# 0.84992f
C10 a_636_n900# a_396_n992# 0.21274f
C11 a_n1756_n900# a_n1668_n992# 0.21274f
C12 a_n52_n900# a_n292_n992# 0.21274f
C13 a_980_n900# a_1324_n900# 0.27776f
C14 a_n1324_n992# a_n1668_n992# 0.05997f
C15 a_n980_n992# w_n1918_n1110# 0.85023f
C16 a_n740_n900# a_n1084_n900# 0.27776f
C17 a_740_n992# a_1084_n992# 0.05997f
C18 a_n292_n992# w_n1918_n1110# 0.84961f
C19 a_n740_n900# a_n396_n900# 0.27776f
C20 a_n52_n900# w_n1918_n1110# 0.37122f
C21 a_n52_n900# a_292_n900# 0.27776f
C22 a_292_n900# w_n1918_n1110# 0.37123f
C23 a_n1428_n900# a_n1756_n900# 0.27776f
C24 a_1324_n900# w_n1918_n1110# 0.37128f
C25 a_636_n900# a_740_n992# 0.21274f
C26 a_n1428_n900# a_n1324_n992# 0.21274f
C27 a_1084_n992# a_1428_n992# 0.05997f
C28 a_n292_n992# a_52_n992# 0.05997f
C29 w_n1918_n1110# a_n1668_n992# 0.89309f
C30 w_n1918_n1110# a_396_n992# 0.84992f
C31 a_292_n900# a_396_n992# 0.21274f
C32 a_1668_n900# w_n1918_n1110# 1.17199f
C33 a_n52_n900# a_52_n992# 0.21274f
C34 a_980_n900# a_740_n992# 0.21274f
C35 a_n1084_n900# a_n1324_n992# 0.21274f
C36 a_1324_n900# a_1668_n900# 0.27776f
C37 a_n740_n900# a_n636_n992# 0.21274f
C38 w_n1918_n1110# a_52_n992# 0.84961f
C39 a_n740_n900# a_n980_n992# 0.21274f
C40 a_292_n900# a_52_n992# 0.21274f
C41 a_980_n900# a_1084_n992# 0.21274f
C42 a_n1084_n900# a_n980_n992# 0.21274f
C43 a_n396_n900# a_n636_n992# 0.21274f
C44 a_n1428_n900# w_n1918_n1110# 0.37128f
C45 a_52_n992# a_396_n992# 0.05997f
C46 a_n396_n900# a_n292_n992# 0.21274f
C47 a_740_n992# w_n1918_n1110# 0.85023f
C48 a_n740_n900# w_n1918_n1110# 0.37123f
C49 a_n1084_n900# w_n1918_n1110# 0.37124f
C50 a_n1428_n900# a_n1668_n992# 0.21274f
C51 a_n52_n900# a_n396_n900# 0.27776f
C52 a_636_n900# a_980_n900# 0.27776f
C53 a_1084_n992# w_n1918_n1110# 0.85112f
C54 a_740_n992# a_396_n992# 0.05997f
C55 a_n396_n900# w_n1918_n1110# 0.37123f
C56 a_1324_n900# a_1084_n992# 0.21274f
C57 a_n1324_n992# a_n980_n992# 0.05997f
C58 a_n980_n992# a_n636_n992# 0.05997f
C59 a_1428_n992# w_n1918_n1110# 0.89309f
C60 a_1668_n900# VSUBS 0.0367f
C61 a_1324_n900# VSUBS 0.06825f
C62 a_980_n900# VSUBS 0.0631f
C63 a_636_n900# VSUBS 0.0631f
C64 a_292_n900# VSUBS 0.0631f
C65 a_n52_n900# VSUBS 0.0631f
C66 a_n396_n900# VSUBS 0.0631f
C67 a_n740_n900# VSUBS 0.0631f
C68 a_n1084_n900# VSUBS 0.0631f
C69 a_n1428_n900# VSUBS 0.06825f
C70 a_n1756_n900# VSUBS 0.0367f
C71 w_n1918_n1110# VSUBS 27.4178f
.ends

.subckt pfet_03v3_UB86XQ a_n2700_n1120# a_2356_n1028# a_n2460_1260# a_n1324_24# a_740_24#
+ a_n2356_n1120# a_n1428_n2172# a_n1668_1168# a_2460_n1120# a_n2012_n2264# a_2460_24#
+ a_2116_n2264# a_1668_n2172# a_n1084_n2172# a_2012_116# a_980_n2172# a_n740_n2172#
+ a_n396_n2172# a_n2700_24# a_n636_1168# a_n980_24# a_52_n2264# a_740_1168# a_52_24#
+ a_n2788_n1028# a_2700_116# a_2700_1260# a_n2460_n1028# a_396_24# a_2116_24# a_n2700_n2264#
+ a_2116_1168# a_1772_24# a_n2356_n2264# a_n1772_n2172# a_1772_1168# a_2012_1260#
+ a_n52_n1028# a_2460_n2264# a_2012_n2172# a_636_n1028# a_52_1168# a_n2116_1260# a_1324_n1028#
+ a_n636_24# w_n2950_n2382# a_n1324_n1120# a_n1772_1260# a_1428_n1120# a_292_n1028#
+ a_n2356_24# a_1084_1168# a_740_n1120# a_n636_n1120# a_396_n1120# a_n2700_1168# a_980_1260#
+ a_1084_n1120# a_n396_116# a_n740_1260# a_n292_n1120# a_n1084_1260# a_1428_24# a_396_1168#
+ a_n2116_n2172# a_2356_1260# a_n2012_1168# a_n1428_n1028# a_2700_n2172# a_292_1260#
+ a_2356_n2172# a_n1084_116# a_1668_n1028# a_292_116# a_n1084_n1028# a_n1668_n1120#
+ a_980_n1028# a_n52_1260# a_n1668_24# a_n740_n1028# a_n396_n1028# a_1772_n1120# a_n1324_n2264#
+ a_1428_1168# a_n1772_116# a_1428_n2264# a_740_n2264# a_n980_n1120# a_n636_n2264#
+ a_396_n2264# a_1324_1260# a_980_116# a_1084_n2264# a_n740_116# a_n1428_1260# a_n2788_1260#
+ a_n2356_1168# a_n2788_n2172# a_n292_n2264# a_n52_116# a_n2460_n2172# a_n396_1260#
+ a_636_1260# a_n1772_n1028# a_n2460_116# a_n2788_116# a_2012_n1028# a_1668_116# a_n980_1168#
+ a_n2012_n1120# a_n2012_24# a_2116_n1120# a_n1668_n2264# a_n52_n2172# a_n292_24#
+ a_n1428_116# a_636_n2172# a_1668_1260# a_n1324_1168# a_636_116# a_1772_n2264# a_1324_n2172#
+ a_292_n2172# a_n292_1168# a_n980_n2264# a_52_n1120# a_2460_1168# a_2356_116# a_1084_24#
+ a_1324_116# a_n2116_n1028# a_n2116_116# a_2700_n1028# VSUBS
X0 a_n1772_116# a_n2012_24# a_n2116_116# w_n2950_n2382# pfet_03v3 ad=1.1856p pd=5.08u as=1.1856p ps=5.08u w=4.56u l=1.2u
X1 a_n1772_1260# a_n2012_1168# a_n2116_1260# w_n2950_n2382# pfet_03v3 ad=1.1856p pd=5.08u as=1.1856p ps=5.08u w=4.56u l=1.2u
X2 a_636_n2172# a_396_n2264# a_292_n2172# w_n2950_n2382# pfet_03v3 ad=1.1856p pd=5.08u as=1.1856p ps=5.08u w=4.56u l=1.2u
X3 a_1324_n2172# a_1084_n2264# a_980_n2172# w_n2950_n2382# pfet_03v3 ad=1.1856p pd=5.08u as=1.1856p ps=5.08u w=4.56u l=1.2u
X4 a_2356_n2172# a_2116_n2264# a_2012_n2172# w_n2950_n2382# pfet_03v3 ad=1.1856p pd=5.08u as=1.1856p ps=5.08u w=4.56u l=1.2u
X5 a_1668_1260# a_1428_1168# a_1324_1260# w_n2950_n2382# pfet_03v3 ad=1.1856p pd=5.08u as=1.1856p ps=5.08u w=4.56u l=1.2u
X6 a_1324_116# a_1084_24# a_980_116# w_n2950_n2382# pfet_03v3 ad=1.1856p pd=5.08u as=1.1856p ps=5.08u w=4.56u l=1.2u
X7 a_n740_n2172# a_n980_n2264# a_n1084_n2172# w_n2950_n2382# pfet_03v3 ad=1.1856p pd=5.08u as=1.1856p ps=5.08u w=4.56u l=1.2u
X8 a_n2116_1260# a_n2356_1168# a_n2460_1260# w_n2950_n2382# pfet_03v3 ad=1.1856p pd=5.08u as=1.1856p ps=5.08u w=4.56u l=1.2u
X9 a_n2460_1260# a_n2700_1168# a_n2788_1260# w_n2950_n2382# pfet_03v3 ad=1.1856p pd=5.08u as=2.0064p ps=10u w=4.56u l=1.2u
X10 a_1668_116# a_1428_24# a_1324_116# w_n2950_n2382# pfet_03v3 ad=1.1856p pd=5.08u as=1.1856p ps=5.08u w=4.56u l=1.2u
X11 a_n1428_n1028# a_n1668_n1120# a_n1772_n1028# w_n2950_n2382# pfet_03v3 ad=1.1856p pd=5.08u as=1.1856p ps=5.08u w=4.56u l=1.2u
X12 a_2012_n1028# a_1772_n1120# a_1668_n1028# w_n2950_n2382# pfet_03v3 ad=1.1856p pd=5.08u as=1.1856p ps=5.08u w=4.56u l=1.2u
X13 a_636_1260# a_396_1168# a_292_1260# w_n2950_n2382# pfet_03v3 ad=1.1856p pd=5.08u as=1.1856p ps=5.08u w=4.56u l=1.2u
X14 a_636_116# a_396_24# a_292_116# w_n2950_n2382# pfet_03v3 ad=1.1856p pd=5.08u as=1.1856p ps=5.08u w=4.56u l=1.2u
X15 a_980_116# a_740_24# a_636_116# w_n2950_n2382# pfet_03v3 ad=1.1856p pd=5.08u as=1.1856p ps=5.08u w=4.56u l=1.2u
X16 a_n1428_116# a_n1668_24# a_n1772_116# w_n2950_n2382# pfet_03v3 ad=1.1856p pd=5.08u as=1.1856p ps=5.08u w=4.56u l=1.2u
X17 a_980_1260# a_740_1168# a_636_1260# w_n2950_n2382# pfet_03v3 ad=1.1856p pd=5.08u as=1.1856p ps=5.08u w=4.56u l=1.2u
X18 a_n2116_n1028# a_n2356_n1120# a_n2460_n1028# w_n2950_n2382# pfet_03v3 ad=1.1856p pd=5.08u as=1.1856p ps=5.08u w=4.56u l=1.2u
X19 a_2700_n1028# a_2460_n1120# a_2356_n1028# w_n2950_n2382# pfet_03v3 ad=2.0064p pd=10u as=1.1856p ps=5.08u w=4.56u l=1.2u
X20 a_n1428_n2172# a_n1668_n2264# a_n1772_n2172# w_n2950_n2382# pfet_03v3 ad=1.1856p pd=5.08u as=1.1856p ps=5.08u w=4.56u l=1.2u
X21 a_2012_n2172# a_1772_n2264# a_1668_n2172# w_n2950_n2382# pfet_03v3 ad=1.1856p pd=5.08u as=1.1856p ps=5.08u w=4.56u l=1.2u
X22 a_1324_1260# a_1084_1168# a_980_1260# w_n2950_n2382# pfet_03v3 ad=1.1856p pd=5.08u as=1.1856p ps=5.08u w=4.56u l=1.2u
X23 a_n2116_n2172# a_n2356_n2264# a_n2460_n2172# w_n2950_n2382# pfet_03v3 ad=1.1856p pd=5.08u as=1.1856p ps=5.08u w=4.56u l=1.2u
X24 a_2700_n2172# a_2460_n2264# a_2356_n2172# w_n2950_n2382# pfet_03v3 ad=2.0064p pd=10u as=1.1856p ps=5.08u w=4.56u l=1.2u
X25 a_2012_1260# a_1772_1168# a_1668_1260# w_n2950_n2382# pfet_03v3 ad=1.1856p pd=5.08u as=1.1856p ps=5.08u w=4.56u l=1.2u
X26 a_n396_1260# a_n636_1168# a_n740_1260# w_n2950_n2382# pfet_03v3 ad=1.1856p pd=5.08u as=1.1856p ps=5.08u w=4.56u l=1.2u
X27 a_n396_n1028# a_n636_n1120# a_n740_n1028# w_n2950_n2382# pfet_03v3 ad=1.1856p pd=5.08u as=1.1856p ps=5.08u w=4.56u l=1.2u
X28 a_n1084_116# a_n1324_24# a_n1428_116# w_n2950_n2382# pfet_03v3 ad=1.1856p pd=5.08u as=1.1856p ps=5.08u w=4.56u l=1.2u
X29 a_2700_116# a_2460_24# a_2356_116# w_n2950_n2382# pfet_03v3 ad=2.0064p pd=10u as=1.1856p ps=5.08u w=4.56u l=1.2u
X30 a_n740_1260# a_n980_1168# a_n1084_1260# w_n2950_n2382# pfet_03v3 ad=1.1856p pd=5.08u as=1.1856p ps=5.08u w=4.56u l=1.2u
X31 a_2356_1260# a_2116_1168# a_2012_1260# w_n2950_n2382# pfet_03v3 ad=1.1856p pd=5.08u as=1.1856p ps=5.08u w=4.56u l=1.2u
X32 a_n740_116# a_n980_24# a_n1084_116# w_n2950_n2382# pfet_03v3 ad=1.1856p pd=5.08u as=1.1856p ps=5.08u w=4.56u l=1.2u
X33 a_n396_n2172# a_n636_n2264# a_n740_n2172# w_n2950_n2382# pfet_03v3 ad=1.1856p pd=5.08u as=1.1856p ps=5.08u w=4.56u l=1.2u
X34 a_n52_n1028# a_n292_n1120# a_n396_n1028# w_n2950_n2382# pfet_03v3 ad=1.1856p pd=5.08u as=1.1856p ps=5.08u w=4.56u l=1.2u
X35 a_n2460_116# a_n2700_24# a_n2788_116# w_n2950_n2382# pfet_03v3 ad=1.1856p pd=5.08u as=2.0064p ps=10u w=4.56u l=1.2u
X36 a_n1084_1260# a_n1324_1168# a_n1428_1260# w_n2950_n2382# pfet_03v3 ad=1.1856p pd=5.08u as=1.1856p ps=5.08u w=4.56u l=1.2u
X37 a_n1084_n1028# a_n1324_n1120# a_n1428_n1028# w_n2950_n2382# pfet_03v3 ad=1.1856p pd=5.08u as=1.1856p ps=5.08u w=4.56u l=1.2u
X38 a_980_n1028# a_740_n1120# a_636_n1028# w_n2950_n2382# pfet_03v3 ad=1.1856p pd=5.08u as=1.1856p ps=5.08u w=4.56u l=1.2u
X39 a_n52_n2172# a_n292_n2264# a_n396_n2172# w_n2950_n2382# pfet_03v3 ad=1.1856p pd=5.08u as=1.1856p ps=5.08u w=4.56u l=1.2u
X40 a_n1428_1260# a_n1668_1168# a_n1772_1260# w_n2950_n2382# pfet_03v3 ad=1.1856p pd=5.08u as=1.1856p ps=5.08u w=4.56u l=1.2u
X41 a_n52_1260# a_n292_1168# a_n396_1260# w_n2950_n2382# pfet_03v3 ad=1.1856p pd=5.08u as=1.1856p ps=5.08u w=4.56u l=1.2u
X42 a_n52_116# a_n292_24# a_n396_116# w_n2950_n2382# pfet_03v3 ad=1.1856p pd=5.08u as=1.1856p ps=5.08u w=4.56u l=1.2u
X43 a_980_n2172# a_740_n2264# a_636_n2172# w_n2950_n2382# pfet_03v3 ad=1.1856p pd=5.08u as=1.1856p ps=5.08u w=4.56u l=1.2u
X44 a_2356_116# a_2116_24# a_2012_116# w_n2950_n2382# pfet_03v3 ad=1.1856p pd=5.08u as=1.1856p ps=5.08u w=4.56u l=1.2u
X45 a_n1772_n1028# a_n2012_n1120# a_n2116_n1028# w_n2950_n2382# pfet_03v3 ad=1.1856p pd=5.08u as=1.1856p ps=5.08u w=4.56u l=1.2u
X46 a_n1084_n2172# a_n1324_n2264# a_n1428_n2172# w_n2950_n2382# pfet_03v3 ad=1.1856p pd=5.08u as=1.1856p ps=5.08u w=4.56u l=1.2u
X47 a_n396_116# a_n636_24# a_n740_116# w_n2950_n2382# pfet_03v3 ad=1.1856p pd=5.08u as=1.1856p ps=5.08u w=4.56u l=1.2u
X48 a_292_116# a_52_24# a_n52_116# w_n2950_n2382# pfet_03v3 ad=1.1856p pd=5.08u as=1.1856p ps=5.08u w=4.56u l=1.2u
X49 a_292_n1028# a_52_n1120# a_n52_n1028# w_n2950_n2382# pfet_03v3 ad=1.1856p pd=5.08u as=1.1856p ps=5.08u w=4.56u l=1.2u
X50 a_292_1260# a_52_1168# a_n52_1260# w_n2950_n2382# pfet_03v3 ad=1.1856p pd=5.08u as=1.1856p ps=5.08u w=4.56u l=1.2u
X51 a_n2116_116# a_n2356_24# a_n2460_116# w_n2950_n2382# pfet_03v3 ad=1.1856p pd=5.08u as=1.1856p ps=5.08u w=4.56u l=1.2u
X52 a_n1772_n2172# a_n2012_n2264# a_n2116_n2172# w_n2950_n2382# pfet_03v3 ad=1.1856p pd=5.08u as=1.1856p ps=5.08u w=4.56u l=1.2u
X53 a_2700_1260# a_2460_1168# a_2356_1260# w_n2950_n2382# pfet_03v3 ad=2.0064p pd=10u as=1.1856p ps=5.08u w=4.56u l=1.2u
X54 a_n2460_n1028# a_n2700_n1120# a_n2788_n1028# w_n2950_n2382# pfet_03v3 ad=1.1856p pd=5.08u as=2.0064p ps=10u w=4.56u l=1.2u
X55 a_1668_n1028# a_1428_n1120# a_1324_n1028# w_n2950_n2382# pfet_03v3 ad=1.1856p pd=5.08u as=1.1856p ps=5.08u w=4.56u l=1.2u
X56 a_292_n2172# a_52_n2264# a_n52_n2172# w_n2950_n2382# pfet_03v3 ad=1.1856p pd=5.08u as=1.1856p ps=5.08u w=4.56u l=1.2u
X57 a_2012_116# a_1772_24# a_1668_116# w_n2950_n2382# pfet_03v3 ad=1.1856p pd=5.08u as=1.1856p ps=5.08u w=4.56u l=1.2u
X58 a_n2460_n2172# a_n2700_n2264# a_n2788_n2172# w_n2950_n2382# pfet_03v3 ad=1.1856p pd=5.08u as=2.0064p ps=10u w=4.56u l=1.2u
X59 a_636_n1028# a_396_n1120# a_292_n1028# w_n2950_n2382# pfet_03v3 ad=1.1856p pd=5.08u as=1.1856p ps=5.08u w=4.56u l=1.2u
X60 a_2356_n1028# a_2116_n1120# a_2012_n1028# w_n2950_n2382# pfet_03v3 ad=1.1856p pd=5.08u as=1.1856p ps=5.08u w=4.56u l=1.2u
X61 a_1668_n2172# a_1428_n2264# a_1324_n2172# w_n2950_n2382# pfet_03v3 ad=1.1856p pd=5.08u as=1.1856p ps=5.08u w=4.56u l=1.2u
X62 a_n740_n1028# a_n980_n1120# a_n1084_n1028# w_n2950_n2382# pfet_03v3 ad=1.1856p pd=5.08u as=1.1856p ps=5.08u w=4.56u l=1.2u
X63 a_1324_n1028# a_1084_n1120# a_980_n1028# w_n2950_n2382# pfet_03v3 ad=1.1856p pd=5.08u as=1.1856p ps=5.08u w=4.56u l=1.2u
C0 a_1668_1260# a_1324_1260# 0.14043f
C1 a_n2700_n1120# a_n2460_n1028# 0.10756f
C2 a_292_n1028# a_292_n2172# 0.0083f
C3 a_n52_116# a_n52_1260# 0.0083f
C4 w_n2950_n2382# a_n1668_n1120# 0.29665f
C5 a_396_n1120# a_52_n1120# 0.05997f
C6 w_n2950_n2382# a_n2116_n1028# 0.16695f
C7 a_2012_116# a_2012_1260# 0.0083f
C8 a_n2700_1168# a_n2700_24# 0.22367f
C9 w_n2950_n2382# a_n2356_24# 0.29785f
C10 a_n1668_1168# a_n1668_24# 0.22367f
C11 w_n2950_n2382# a_n1084_1260# 0.18803f
C12 a_n636_n1120# a_n292_n1120# 0.05997f
C13 a_n636_1168# a_n292_1168# 0.05997f
C14 a_1772_n1120# a_1772_n2264# 0.22367f
C15 w_n2950_n2382# a_n2460_n1028# 0.16699f
C16 a_n1084_n1028# a_n1084_n2172# 0.0083f
C17 a_n1084_116# a_n1084_n1028# 0.0083f
C18 a_n2460_116# a_n2460_1260# 0.0083f
C19 w_n2950_n2382# a_1772_1168# 0.57017f
C20 a_n636_24# a_n636_1168# 0.22367f
C21 a_n1772_n2172# a_n1772_n1028# 0.0083f
C22 a_980_116# a_980_1260# 0.0083f
C23 a_292_1260# a_n52_1260# 0.14043f
C24 a_1084_n2264# a_980_n2172# 0.10756f
C25 a_n740_116# a_n1084_116# 0.14043f
C26 a_2012_116# a_2356_116# 0.14043f
C27 a_636_n2172# a_980_n2172# 0.14043f
C28 a_n1084_n1028# a_n1324_n1120# 0.10756f
C29 a_740_n2264# a_980_n2172# 0.10756f
C30 a_n2700_1168# a_n2356_1168# 0.05997f
C31 w_n2950_n2382# a_n2012_1168# 0.57017f
C32 a_740_n2264# a_1084_n2264# 0.05997f
C33 w_n2950_n2382# a_n636_1168# 0.56949f
C34 a_636_116# a_980_116# 0.14043f
C35 a_n2012_n1120# a_n2012_24# 0.22367f
C36 a_n1324_n1120# a_n980_n1120# 0.05997f
C37 a_396_n2264# a_636_n2172# 0.10756f
C38 a_740_n2264# a_636_n2172# 0.10756f
C39 a_740_n2264# a_396_n2264# 0.05997f
C40 a_n2700_n2264# a_n2356_n2264# 0.05997f
C41 w_n2950_n2382# a_n740_1260# 0.18803f
C42 a_1772_1168# a_2116_1168# 0.05997f
C43 a_52_n2264# a_396_n2264# 0.05997f
C44 a_980_1260# a_1324_1260# 0.14043f
C45 a_2356_116# a_2356_n1028# 0.0083f
C46 a_1428_1168# a_1324_1260# 0.10756f
C47 a_n52_1260# a_52_1168# 0.10756f
C48 a_2700_n1028# a_2700_n2172# 0.0083f
C49 a_n1772_n1028# a_n2012_n1120# 0.10756f
C50 a_n1324_24# a_n980_24# 0.05997f
C51 w_n2950_n2382# a_n1324_24# 0.29633f
C52 a_n1772_n2172# a_n1428_n2172# 0.14043f
C53 a_n2356_1168# a_n2460_1260# 0.10756f
C54 a_980_116# a_1084_24# 0.10756f
C55 a_n636_n2264# a_n292_n2264# 0.05997f
C56 a_n2012_n2264# a_n1668_n2264# 0.05997f
C57 a_980_116# a_740_24# 0.10756f
C58 w_n2950_n2382# a_n292_1168# 0.56949f
C59 w_n2950_n2382# a_n2788_1260# 0.59408f
C60 a_2700_n1028# a_2460_n1120# 0.10756f
C61 a_740_1168# a_980_1260# 0.10756f
C62 a_52_24# a_396_24# 0.05997f
C63 a_n2012_1168# a_n1668_1168# 0.05997f
C64 w_n2950_n2382# a_n292_n2264# 0.56949f
C65 a_n1668_n2264# w_n2950_n2382# 0.56987f
C66 a_n396_n2172# a_n292_n2264# 0.10756f
C67 a_636_116# a_396_24# 0.10756f
C68 a_636_116# a_740_24# 0.10756f
C69 a_n636_24# a_n980_24# 0.05997f
C70 w_n2950_n2382# a_n636_24# 0.29627f
C71 a_1324_n2172# a_1668_n2172# 0.14043f
C72 a_2356_n1028# a_2700_n1028# 0.14043f
C73 w_n2950_n2382# a_n2700_n1120# 0.33982f
C74 a_2356_n1028# a_2460_n1120# 0.10756f
C75 a_1668_n2172# w_n2950_n2382# 0.18805f
C76 a_n1772_116# a_n1772_1260# 0.0083f
C77 a_2116_n1120# a_2460_n1120# 0.05997f
C78 w_n2950_n2382# a_n636_n2264# 0.56949f
C79 a_n396_n2172# a_n636_n2264# 0.10756f
C80 a_n2012_n2264# w_n2950_n2382# 0.57017f
C81 a_n2116_n2172# a_n2116_n1028# 0.0083f
C82 a_396_24# a_396_1168# 0.22367f
C83 a_n1324_1168# a_n1084_1260# 0.10756f
C84 w_n2950_n2382# a_2700_116# 0.57484f
C85 a_n740_116# a_n740_1260# 0.0083f
C86 a_636_n2172# a_636_n1028# 0.0083f
C87 a_1324_n2172# w_n2950_n2382# 0.18804f
C88 a_2356_n1028# a_2116_n1120# 0.10756f
C89 a_n292_24# a_n292_1168# 0.22367f
C90 w_n2950_n2382# a_n980_24# 0.29627f
C91 a_n2460_n2172# a_n2460_n1028# 0.0083f
C92 a_n740_n2172# a_n636_n2264# 0.10756f
C93 a_636_116# a_636_n1028# 0.0083f
C94 w_n2950_n2382# a_n396_n2172# 0.18803f
C95 a_396_1168# a_740_1168# 0.05997f
C96 a_1668_116# w_n2950_n2382# 0.16694f
C97 a_n2116_1260# a_n1772_1260# 0.14043f
C98 a_n636_24# a_n292_24# 0.05997f
C99 a_1772_n1120# a_2116_n1120# 0.05997f
C100 a_1772_24# a_1772_1168# 0.22367f
C101 a_740_24# a_1084_24# 0.05997f
C102 a_292_116# w_n2950_n2382# 0.16693f
C103 a_n1428_116# a_n1428_1260# 0.0083f
C104 w_n2950_n2382# a_n740_n2172# 0.18803f
C105 w_n2950_n2382# a_n52_n1028# 0.16693f
C106 a_n740_n2172# a_n396_n2172# 0.14043f
C107 a_1324_116# w_n2950_n2382# 0.16693f
C108 a_n2700_1168# a_n2788_1260# 0.10756f
C109 a_n1668_n1120# a_n2012_n1120# 0.05997f
C110 a_1324_n2172# a_1324_n1028# 0.0083f
C111 a_1324_116# a_1668_116# 0.14043f
C112 a_396_24# a_740_24# 0.05997f
C113 a_n52_116# w_n2950_n2382# 0.16693f
C114 w_n2950_n2382# a_1324_n1028# 0.16693f
C115 w_n2950_n2382# a_n396_n1028# 0.16693f
C116 a_n396_n2172# a_n396_n1028# 0.0083f
C117 a_n2012_n1120# a_n2116_n1028# 0.10756f
C118 w_n2950_n2382# a_n292_24# 0.29627f
C119 a_n980_n2264# a_n1084_n2172# 0.10756f
C120 a_n396_116# a_n636_24# 0.10756f
C121 a_n636_24# a_n636_n1120# 0.22367f
C122 w_n2950_n2382# a_980_n1028# 0.16693f
C123 a_n52_116# a_292_116# 0.14043f
C124 a_n636_n2264# a_n636_n1120# 0.22367f
C125 a_n2356_n1120# a_n2116_n1028# 0.10756f
C126 a_n52_116# a_n52_n1028# 0.0083f
C127 a_1668_1260# a_1772_1168# 0.10756f
C128 a_n396_n1028# a_n52_n1028# 0.14043f
C129 w_n2950_n2382# a_740_n1120# 0.29627f
C130 a_740_1168# a_740_24# 0.22367f
C131 a_n1324_n2264# a_n1084_n2172# 0.10756f
C132 a_1668_n2172# a_1668_n1028# 0.0083f
C133 w_n2950_n2382# a_2116_1168# 0.57107f
C134 a_n2356_24# a_n2356_n1120# 0.22367f
C135 w_n2950_n2382# a_n740_n1028# 0.16693f
C136 a_n740_116# a_n636_24# 0.10756f
C137 a_1324_116# a_1324_n1028# 0.0083f
C138 a_1084_1168# a_980_1260# 0.10756f
C139 w_n2950_n2382# a_2012_n1028# 0.16695f
C140 a_1428_1168# a_1084_1168# 0.05997f
C141 a_n1428_1260# a_n1084_1260# 0.14043f
C142 a_n2116_116# a_n1772_116# 0.14043f
C143 a_n2356_n1120# a_n2460_n1028# 0.10756f
C144 w_n2950_n2382# a_n2700_1168# 0.61304f
C145 a_n396_116# w_n2950_n2382# 0.16693f
C146 w_n2950_n2382# a_n636_n1120# 0.29627f
C147 w_n2950_n2382# a_396_n1120# 0.29627f
C148 a_n1324_n2264# a_n1428_n2172# 0.10756f
C149 w_n2950_n2382# a_n1084_n1028# 0.16693f
C150 w_n2950_n2382# a_292_1260# 0.18803f
C151 a_n52_116# a_n292_24# 0.10756f
C152 a_n740_n1028# a_n740_n2172# 0.0083f
C153 w_n2950_n2382# a_1668_n1028# 0.16694f
C154 a_52_24# a_52_n1120# 0.22367f
C155 a_n2460_1260# a_n2788_1260# 0.14043f
C156 w_n2950_n2382# a_1428_n1120# 0.29665f
C157 a_n1324_1168# a_n1324_24# 0.22367f
C158 a_n1772_116# a_n2012_24# 0.10756f
C159 w_n2950_n2382# a_n1668_1168# 0.56987f
C160 a_n740_116# a_n980_24# 0.10756f
C161 a_n1324_n2264# a_n1324_n1120# 0.22367f
C162 a_1668_116# a_1668_n1028# 0.0083f
C163 a_n980_n1120# a_n980_24# 0.22367f
C164 a_n2788_116# a_n2788_n1028# 0.0083f
C165 a_980_n1028# a_1324_n1028# 0.14043f
C166 a_n740_116# w_n2950_n2382# 0.16693f
C167 w_n2950_n2382# a_n980_n1120# 0.29627f
C168 a_292_116# a_292_1260# 0.0083f
C169 a_n292_1168# a_52_1168# 0.05997f
C170 a_n2116_116# a_n2116_1260# 0.0083f
C171 a_n740_n1028# a_n396_n1028# 0.14043f
C172 a_52_n2264# a_52_n1120# 0.22367f
C173 w_n2950_n2382# a_1084_n1120# 0.29633f
C174 a_n2116_116# a_n2012_24# 0.10756f
C175 a_n52_116# a_n396_116# 0.14043f
C176 a_980_n1028# a_740_n1120# 0.10756f
C177 a_n1668_n2264# a_n1772_n2172# 0.10756f
C178 a_n396_116# a_n396_n1028# 0.0083f
C179 a_n636_n1120# a_n396_n1028# 0.10756f
C180 a_n396_116# a_n292_24# 0.10756f
C181 a_1668_n1028# a_1324_n1028# 0.14043f
C182 a_292_n1028# a_636_n1028# 0.14043f
C183 a_n292_n2264# a_n52_n2172# 0.10756f
C184 a_1428_n1120# a_1324_n1028# 0.10756f
C185 a_n1772_n1028# a_n1772_116# 0.0083f
C186 a_n2012_n2264# a_n1772_n2172# 0.10756f
C187 a_2012_1260# a_1772_1168# 0.10756f
C188 w_n2950_n2382# a_n2460_1260# 0.18809f
C189 w_n2950_n2382# a_2460_1168# 0.61304f
C190 a_396_n1120# a_740_n1120# 0.05997f
C191 a_n740_n1028# a_n636_n1120# 0.10756f
C192 a_1084_1168# a_1324_1260# 0.10756f
C193 a_n1084_n1028# a_n740_n1028# 0.14043f
C194 a_2460_24# a_2700_116# 0.10756f
C195 a_1084_n1120# a_1324_n1028# 0.10756f
C196 w_n2950_n2382# a_292_n2172# 0.18803f
C197 a_1084_1168# a_1084_24# 0.22367f
C198 w_n2950_n2382# a_52_1168# 0.56949f
C199 a_n1772_n2172# w_n2950_n2382# 0.18805f
C200 a_n2012_n2264# a_n2116_n2172# 0.10756f
C201 a_1668_n1028# a_2012_n1028# 0.14043f
C202 w_n2950_n2382# a_2460_24# 0.33982f
C203 w_n2950_n2382# a_636_1260# 0.18803f
C204 a_n740_n1028# a_n980_n1120# 0.10756f
C205 a_n740_116# a_n740_n1028# 0.0083f
C206 a_n2460_116# a_n2116_116# 0.14043f
C207 a_2460_n2264# w_n2950_n2382# 0.61304f
C208 a_1084_n1120# a_980_n1028# 0.10756f
C209 w_n2950_n2382# a_n52_n2172# 0.18803f
C210 a_n396_n2172# a_n52_n2172# 0.14043f
C211 a_n1772_116# a_n1668_24# 0.10756f
C212 a_n2460_n2172# w_n2950_n2382# 0.18809f
C213 a_1084_n1120# a_740_n1120# 0.05997f
C214 w_n2950_n2382# a_n1324_1168# 0.56955f
C215 a_n2116_n2172# w_n2950_n2382# 0.18806f
C216 a_n740_116# a_n396_116# 0.14043f
C217 w_n2950_n2382# a_2116_24# 0.29785f
C218 a_n980_n1120# a_n636_n1120# 0.05997f
C219 a_1668_n1028# a_1428_n1120# 0.10756f
C220 a_n1084_n1028# a_n980_n1120# 0.10756f
C221 a_1428_1168# a_1772_1168# 0.05997f
C222 w_n2950_n2382# a_1772_24# 0.29695f
C223 a_2116_n2264# w_n2950_n2382# 0.57107f
C224 a_n2788_n2172# w_n2950_n2382# 0.59408f
C225 a_n52_n1028# a_n52_n2172# 0.0083f
C226 a_1668_116# a_1772_24# 0.10756f
C227 a_2012_n2172# a_1668_n2172# 0.14043f
C228 a_740_1168# a_1084_1168# 0.05997f
C229 w_n2950_n2382# a_2356_1260# 0.18809f
C230 w_n2950_n2382# a_1428_24# 0.29665f
C231 a_n1772_n1028# a_n1428_n1028# 0.14043f
C232 a_2356_n2172# w_n2950_n2382# 0.18809f
C233 a_1084_n1120# a_1428_n1120# 0.05997f
C234 a_2116_1168# a_2460_1168# 0.05997f
C235 a_1668_n2172# a_1772_n2264# 0.10756f
C236 a_1668_116# a_1428_24# 0.10756f
C237 a_n2012_24# a_n1668_24# 0.05997f
C238 a_n2788_n1028# a_n2460_n1028# 0.14043f
C239 a_n2012_n2264# a_n2012_n1120# 0.22367f
C240 a_n2700_1168# a_n2460_1260# 0.10756f
C241 a_2012_n2172# w_n2950_n2382# 0.18806f
C242 a_n1428_116# a_n1772_116# 0.14043f
C243 a_52_n1120# a_292_n1028# 0.10756f
C244 a_n2356_n1120# a_n2700_n1120# 0.05997f
C245 a_1668_n2172# a_1428_n2264# 0.10756f
C246 w_n2950_n2382# a_1668_1260# 0.18805f
C247 a_1324_116# a_1428_24# 0.10756f
C248 a_n980_1168# a_n1084_1260# 0.10756f
C249 w_n2950_n2382# a_1772_n2264# 0.57017f
C250 a_1668_116# a_1668_1260# 0.0083f
C251 w_n2950_n2382# a_n2012_n1120# 0.29695f
C252 a_292_1260# a_52_1168# 0.10756f
C253 a_2116_24# a_2116_1168# 0.22367f
C254 a_n2012_1168# a_n1772_1260# 0.10756f
C255 a_1324_n2172# a_1428_n2264# 0.10756f
C256 a_292_1260# a_636_1260# 0.14043f
C257 w_n2950_n2382# a_1428_n2264# 0.56987f
C258 w_n2950_n2382# a_n2356_n1120# 0.29785f
C259 w_n2950_n2382# a_n1428_1260# 0.18804f
C260 a_n2788_116# a_n2460_116# 0.14043f
C261 a_2356_1260# a_2116_1168# 0.10756f
C262 a_n1668_1168# a_n1324_1168# 0.05997f
C263 a_2700_1260# a_2700_116# 0.0083f
C264 a_n2356_1168# a_n2116_1260# 0.10756f
C265 a_n980_n2264# a_n636_n2264# 0.05997f
C266 w_n2950_n2382# a_2700_1260# 0.59408f
C267 a_n2460_116# a_n2700_24# 0.10756f
C268 a_n2116_116# a_n2116_n1028# 0.0083f
C269 a_n1668_n2264# a_n1324_n2264# 0.05997f
C270 a_n2356_24# a_n2116_116# 0.10756f
C271 a_n1428_n1028# a_n1428_n2172# 0.0083f
C272 a_n1428_116# a_n1428_n1028# 0.0083f
C273 a_n980_1168# a_n636_1168# 0.05997f
C274 a_2012_n2172# a_2012_n1028# 0.0083f
C275 a_1428_n1120# a_1428_24# 0.22367f
C276 a_n396_1260# a_n52_1260# 0.14043f
C277 a_n2788_116# a_n2700_24# 0.10756f
C278 a_n980_n2264# w_n2950_n2382# 0.56949f
C279 a_n1324_n1120# a_n1428_n1028# 0.10756f
C280 a_2460_24# a_2460_1168# 0.22367f
C281 w_n2950_n2382# a_2012_1260# 0.18806f
C282 a_n2356_24# a_n2012_24# 0.05997f
C283 a_n980_1168# a_n740_1260# 0.10756f
C284 a_n292_n1120# a_52_n1120# 0.05997f
C285 a_n1324_n2264# w_n2950_n2382# 0.56955f
C286 a_n1668_n1120# a_n1428_n1028# 0.10756f
C287 a_n980_n2264# a_n740_n2172# 0.10756f
C288 a_n52_n2172# a_292_n2172# 0.14043f
C289 a_n2116_n2172# a_n1772_n2172# 0.14043f
C290 a_2356_116# a_2700_116# 0.14043f
C291 a_n1668_n1120# a_n1772_n1028# 0.10756f
C292 a_2116_24# a_2460_24# 0.05997f
C293 a_n1428_116# a_n1668_24# 0.10756f
C294 a_1324_n2172# a_980_n2172# 0.14043f
C295 a_1428_n1120# a_1428_n2264# 0.22367f
C296 a_2356_1260# a_2460_1168# 0.10756f
C297 w_n2950_n2382# a_980_1260# 0.18803f
C298 a_2356_116# w_n2950_n2382# 0.16699f
C299 w_n2950_n2382# a_1428_1168# 0.56987f
C300 a_n1772_n1028# a_n2116_n1028# 0.14043f
C301 a_n2012_n2264# a_n2356_n2264# 0.05997f
C302 a_1084_n2264# a_1324_n2172# 0.10756f
C303 a_980_n2172# w_n2950_n2382# 0.18803f
C304 a_n2116_n2172# a_n2460_n2172# 0.14043f
C305 a_52_n2264# a_n292_n2264# 0.05997f
C306 a_n1668_1168# a_n1428_1260# 0.10756f
C307 a_n2012_1168# a_n2116_1260# 0.10756f
C308 a_2116_n2264# a_2460_n2264# 0.05997f
C309 a_1084_n2264# w_n2950_n2382# 0.56955f
C310 a_n2700_n2264# a_n2700_n1120# 0.22367f
C311 a_980_116# w_n2950_n2382# 0.16693f
C312 a_n2788_n1028# a_n2700_n1120# 0.10756f
C313 a_n2460_116# a_n2356_24# 0.10756f
C314 a_n2012_1168# a_n2012_24# 0.22367f
C315 a_2116_24# a_1772_24# 0.05997f
C316 a_2012_116# w_n2950_n2382# 0.16695f
C317 a_n2788_n2172# a_n2460_n2172# 0.14043f
C318 a_636_n2172# w_n2950_n2382# 0.18803f
C319 w_n2950_n2382# a_n2356_n2264# 0.57107f
C320 a_2012_1260# a_2116_1168# 0.10756f
C321 a_n1428_n2172# a_n1084_n2172# 0.14043f
C322 a_2356_n2172# a_2460_n2264# 0.10756f
C323 w_n2950_n2382# a_2700_n2172# 0.59408f
C324 w_n2950_n2382# a_52_24# 0.29627f
C325 a_n1428_116# a_n1084_116# 0.14043f
C326 a_396_n2264# w_n2950_n2382# 0.56949f
C327 a_1668_116# a_2012_116# 0.14043f
C328 a_n1668_n1120# a_n1668_24# 0.22367f
C329 a_740_n2264# w_n2950_n2382# 0.56949f
C330 a_n2460_116# a_n2460_n1028# 0.0083f
C331 a_636_116# w_n2950_n2382# 0.16693f
C332 w_n2950_n2382# a_n1772_1260# 0.18805f
C333 a_1324_116# a_980_116# 0.14043f
C334 w_n2950_n2382# a_n2700_n2264# 0.61304f
C335 a_1428_24# a_1772_24# 0.05997f
C336 a_2356_n2172# a_2116_n2264# 0.10756f
C337 w_n2950_n2382# a_n2788_n1028# 0.57484f
C338 a_292_116# a_52_24# 0.10756f
C339 a_52_n2264# w_n2950_n2382# 0.56949f
C340 w_n2950_n2382# a_396_1168# 0.56949f
C341 a_292_116# a_636_116# 0.14043f
C342 a_2700_n1028# a_2700_116# 0.0083f
C343 a_n980_n2264# a_n980_n1120# 0.22367f
C344 a_n2700_24# a_n2356_24# 0.05997f
C345 w_n2950_n2382# a_2700_n1028# 0.57484f
C346 a_980_n2172# a_980_n1028# 0.0083f
C347 a_2012_n2172# a_2116_n2264# 0.10756f
C348 w_n2950_n2382# a_2460_n1120# 0.33982f
C349 a_n52_116# a_52_24# 0.10756f
C350 a_n396_1260# a_n636_1168# 0.10756f
C351 a_980_116# a_980_n1028# 0.0083f
C352 a_52_24# a_n292_24# 0.05997f
C353 a_n980_1168# a_n980_24# 0.22367f
C354 w_n2950_n2382# a_n980_1168# 0.56949f
C355 a_2116_n2264# a_1772_n2264# 0.05997f
C356 a_n1084_116# a_n1084_1260# 0.0083f
C357 w_n2950_n2382# a_1324_1260# 0.18804f
C358 a_2700_1260# a_2460_1168# 0.10756f
C359 a_2012_n2172# a_2356_n2172# 0.14043f
C360 w_n2950_n2382# a_2356_n1028# 0.16699f
C361 w_n2950_n2382# a_2116_n1120# 0.29785f
C362 a_n1324_1168# a_n1428_1260# 0.10756f
C363 w_n2950_n2382# a_1084_24# 0.29633f
C364 a_2012_116# a_2012_n1028# 0.0083f
C365 a_n396_1260# a_n740_1260# 0.14043f
C366 a_n1668_n1120# a_n1324_n1120# 0.05997f
C367 a_740_n2264# a_740_n1120# 0.22367f
C368 w_n2950_n2382# a_1772_n1120# 0.29695f
C369 w_n2950_n2382# a_396_24# 0.29627f
C370 w_n2950_n2382# a_740_24# 0.29627f
C371 a_1324_116# a_1324_1260# 0.0083f
C372 a_396_n2264# a_396_n1120# 0.22367f
C373 a_2012_n2172# a_1772_n2264# 0.10756f
C374 a_n2356_24# a_n2356_1168# 0.22367f
C375 w_n2950_n2382# a_n1772_116# 0.16694f
C376 a_1324_116# a_1084_24# 0.10756f
C377 a_1084_n2264# a_1084_n1120# 0.22367f
C378 a_292_116# a_396_24# 0.10756f
C379 w_n2950_n2382# a_740_1168# 0.56949f
C380 a_n1668_1168# a_n1772_1260# 0.10756f
C381 w_n2950_n2382# a_n2116_116# 0.16695f
C382 a_292_1260# a_396_1168# 0.10756f
C383 a_1428_n2264# a_1772_n2264# 0.05997f
C384 a_2356_1260# a_2700_1260# 0.14043f
C385 w_n2950_n2382# a_636_n1028# 0.16693f
C386 a_n2356_n1120# a_n2012_n1120# 0.05997f
C387 a_n396_1260# a_n292_1168# 0.10756f
C388 w_n2950_n2382# a_n2116_1260# 0.18806f
C389 a_n2460_n1028# a_n2116_n1028# 0.14043f
C390 a_2356_n1028# a_2012_n1028# 0.14043f
C391 a_n1668_24# a_n1324_24# 0.05997f
C392 w_n2950_n2382# a_n2012_24# 0.29695f
C393 a_2116_n1120# a_2012_n1028# 0.10756f
C394 w_n2950_n2382# a_292_n1028# 0.16693f
C395 a_2356_1260# a_2012_1260# 0.14043f
C396 a_636_1260# a_980_1260# 0.14043f
C397 a_2356_116# a_2460_24# 0.10756f
C398 a_n2356_1168# a_n2012_1168# 0.05997f
C399 a_740_n1120# a_740_24# 0.22367f
C400 a_1772_n1120# a_2012_n1028# 0.10756f
C401 a_636_n2172# a_292_n2172# 0.14043f
C402 a_n2788_116# a_n2788_1260# 0.0083f
C403 w_n2950_n2382# a_n1428_n1028# 0.16693f
C404 a_396_n2264# a_292_n2172# 0.10756f
C405 a_292_116# a_292_n1028# 0.0083f
C406 a_2356_116# a_2116_24# 0.10756f
C407 a_n1084_116# a_n1324_24# 0.10756f
C408 a_n52_n1028# a_292_n1028# 0.14043f
C409 a_52_24# a_52_1168# 0.22367f
C410 a_396_n1120# a_396_24# 0.22367f
C411 a_1668_1260# a_2012_1260# 0.14043f
C412 a_1772_n1120# a_1668_n1028# 0.10756f
C413 a_636_116# a_636_1260# 0.0083f
C414 a_2460_n2264# a_2700_n2172# 0.10756f
C415 a_n2460_n2172# a_n2356_n2264# 0.10756f
C416 a_1772_n1120# a_1428_n1120# 0.05997f
C417 w_n2950_n2382# a_n1772_n1028# 0.16694f
C418 w_n2950_n2382# a_n396_1260# 0.18803f
C419 a_52_n2264# a_292_n2172# 0.10756f
C420 a_n2116_n2172# a_n2356_n2264# 0.10756f
C421 a_2012_116# a_2116_24# 0.10756f
C422 a_1084_n1120# a_1084_24# 0.22367f
C423 a_980_n1028# a_636_n1028# 0.14043f
C424 a_n1428_116# a_n1324_24# 0.10756f
C425 a_740_n1120# a_636_n1028# 0.10756f
C426 a_2012_116# a_1772_24# 0.10756f
C427 a_2356_116# a_2356_1260# 0.0083f
C428 a_1428_24# a_1428_1168# 0.22367f
C429 w_n2950_n2382# a_n2460_116# 0.16699f
C430 a_396_1168# a_52_1168# 0.05997f
C431 a_636_1260# a_396_1168# 0.10756f
C432 a_n292_n2264# a_n292_n1120# 0.22367f
C433 a_n2460_n2172# a_n2700_n2264# 0.10756f
C434 a_n1324_n1120# a_n1324_24# 0.22367f
C435 a_52_n2264# a_n52_n2172# 0.10756f
C436 a_n2700_24# a_n2700_n1120# 0.22367f
C437 a_396_n1120# a_636_n1028# 0.10756f
C438 a_2460_24# a_2460_n1120# 0.22367f
C439 a_n52_1260# a_n292_1168# 0.10756f
C440 w_n2950_n2382# a_n2788_116# 0.57484f
C441 a_n1084_1260# a_n740_1260# 0.14043f
C442 a_1668_1260# a_1428_1168# 0.10756f
C443 a_2356_n2172# a_2700_n2172# 0.14043f
C444 a_2460_n2264# a_2460_n1120# 0.22367f
C445 a_n2788_n2172# a_n2700_n2264# 0.10756f
C446 w_n2950_n2382# a_n1668_24# 0.29665f
C447 w_n2950_n2382# a_52_n1120# 0.29627f
C448 a_n2788_n2172# a_n2788_n1028# 0.0083f
C449 w_n2950_n2382# a_1084_1168# 0.56955f
C450 a_396_n1120# a_292_n1028# 0.10756f
C451 a_n1668_n2264# a_n1428_n2172# 0.10756f
C452 a_n980_1168# a_n1324_1168# 0.05997f
C453 w_n2950_n2382# a_n2700_24# 0.33982f
C454 w_n2950_n2382# a_n292_n1120# 0.29627f
C455 a_n52_n1028# a_52_n1120# 0.10756f
C456 w_n2950_n2382# a_n1084_n2172# 0.18803f
C457 a_n1084_116# a_n980_24# 0.10756f
C458 a_n1084_n1028# a_n1428_n1028# 0.14043f
C459 a_1084_n2264# a_1428_n2264# 0.05997f
C460 a_n1084_116# w_n2950_n2382# 0.16693f
C461 a_2116_n1120# a_2116_24# 0.22367f
C462 a_2116_n2264# a_2116_n1120# 0.22367f
C463 a_n1324_n2264# a_n980_n2264# 0.05997f
C464 w_n2950_n2382# a_n52_1260# 0.18803f
C465 a_n52_n1028# a_n292_n1120# 0.10756f
C466 a_n396_116# a_n396_1260# 0.0083f
C467 a_n2356_n1120# a_n2356_n2264# 0.22367f
C468 a_n1668_n2264# a_n1668_n1120# 0.22367f
C469 w_n2950_n2382# a_n1428_n2172# 0.18804f
C470 a_n1428_116# w_n2950_n2382# 0.16693f
C471 a_n636_1168# a_n740_1260# 0.10756f
C472 a_n1084_n2172# a_n740_n2172# 0.14043f
C473 a_2356_n2172# a_2356_n1028# 0.0083f
C474 a_n2460_1260# a_n2116_1260# 0.14043f
C475 a_1772_n1120# a_1772_24# 0.22367f
C476 a_1428_24# a_1084_24# 0.05997f
C477 a_n1772_1260# a_n1428_1260# 0.14043f
C478 a_636_1260# a_740_1168# 0.10756f
C479 a_n396_n1028# a_n292_n1120# 0.10756f
C480 w_n2950_n2382# a_n1324_n1120# 0.29633f
C481 a_n292_24# a_n292_n1120# 0.22367f
C482 w_n2950_n2382# a_n2356_1168# 0.57107f
C483 a_2700_n2172# VSUBS 0.01781f
C484 a_2356_n2172# VSUBS 0.03047f
C485 a_2012_n2172# VSUBS 0.02532f
C486 a_1668_n2172# VSUBS 0.02532f
C487 a_1324_n2172# VSUBS 0.02532f
C488 a_980_n2172# VSUBS 0.02532f
C489 a_636_n2172# VSUBS 0.02532f
C490 a_292_n2172# VSUBS 0.02532f
C491 a_n52_n2172# VSUBS 0.02532f
C492 a_n396_n2172# VSUBS 0.02532f
C493 a_n740_n2172# VSUBS 0.02532f
C494 a_n1084_n2172# VSUBS 0.02532f
C495 a_n1428_n2172# VSUBS 0.02532f
C496 a_n1772_n2172# VSUBS 0.02532f
C497 a_n2116_n2172# VSUBS 0.02532f
C498 a_n2460_n2172# VSUBS 0.03047f
C499 a_n2788_n2172# VSUBS 0.01781f
C500 a_2700_n1028# VSUBS 0.00515f
C501 a_2356_n1028# VSUBS 0.00515f
C502 a_n2460_n1028# VSUBS 0.00515f
C503 a_n2788_n1028# VSUBS 0.00515f
C504 a_2700_116# VSUBS 0.00515f
C505 a_2356_116# VSUBS 0.00515f
C506 a_n2460_116# VSUBS 0.00515f
C507 a_n2788_116# VSUBS 0.00515f
C508 a_2700_1260# VSUBS 0.01781f
C509 a_2356_1260# VSUBS 0.03047f
C510 a_2012_1260# VSUBS 0.02532f
C511 a_1668_1260# VSUBS 0.02532f
C512 a_1324_1260# VSUBS 0.02532f
C513 a_980_1260# VSUBS 0.02532f
C514 a_636_1260# VSUBS 0.02532f
C515 a_292_1260# VSUBS 0.02532f
C516 a_n52_1260# VSUBS 0.02532f
C517 a_n396_1260# VSUBS 0.02532f
C518 a_n740_1260# VSUBS 0.02532f
C519 a_n1084_1260# VSUBS 0.02532f
C520 a_n1428_1260# VSUBS 0.02532f
C521 a_n1772_1260# VSUBS 0.02532f
C522 a_n2116_1260# VSUBS 0.02532f
C523 a_n2460_1260# VSUBS 0.03047f
C524 a_n2788_1260# VSUBS 0.01781f
C525 w_n2950_n2382# VSUBS 87.6741f
.ends

.subckt pfet_03v3_BXNJAZ a_256_n912# a_n52_n820# a_356_n820# a_n868_n820# a_n356_n912#
+ a_460_n912# a_560_n820# a_n560_n912# a_52_n912# a_152_n820# a_n664_n820# a_868_n912#
+ a_n152_n912# w_n1218_n1030# a_968_n820# a_n968_n912# a_n1056_n820# a_n256_n820#
+ a_n460_n820# a_664_n912# a_764_n820# a_n764_n912# VSUBS
X0 a_n868_n820# a_n968_n912# a_n1056_n820# w_n1218_n1030# pfet_03v3 ad=2.132p pd=8.72u as=3.608p ps=17.28u w=8.2u l=0.5u
X1 a_560_n820# a_460_n912# a_356_n820# w_n1218_n1030# pfet_03v3 ad=2.132p pd=8.72u as=2.132p ps=8.72u w=8.2u l=0.5u
X2 a_968_n820# a_868_n912# a_764_n820# w_n1218_n1030# pfet_03v3 ad=3.608p pd=17.28u as=2.132p ps=8.72u w=8.2u l=0.5u
X3 a_n256_n820# a_n356_n912# a_n460_n820# w_n1218_n1030# pfet_03v3 ad=2.132p pd=8.72u as=2.132p ps=8.72u w=8.2u l=0.5u
X4 a_356_n820# a_256_n912# a_152_n820# w_n1218_n1030# pfet_03v3 ad=2.132p pd=8.72u as=2.132p ps=8.72u w=8.2u l=0.5u
X5 a_n664_n820# a_n764_n912# a_n868_n820# w_n1218_n1030# pfet_03v3 ad=2.132p pd=8.72u as=2.132p ps=8.72u w=8.2u l=0.5u
X6 a_152_n820# a_52_n912# a_n52_n820# w_n1218_n1030# pfet_03v3 ad=2.132p pd=8.72u as=2.132p ps=8.72u w=8.2u l=0.5u
X7 a_764_n820# a_664_n912# a_560_n820# w_n1218_n1030# pfet_03v3 ad=2.132p pd=8.72u as=2.132p ps=8.72u w=8.2u l=0.5u
X8 a_n460_n820# a_n560_n912# a_n664_n820# w_n1218_n1030# pfet_03v3 ad=2.132p pd=8.72u as=2.132p ps=8.72u w=8.2u l=0.5u
X9 a_n52_n820# a_n152_n912# a_n256_n820# w_n1218_n1030# pfet_03v3 ad=2.132p pd=8.72u as=2.132p ps=8.72u w=8.2u l=0.5u
C0 a_764_n820# w_n1218_n1030# 0.18238f
C1 w_n1218_n1030# a_n152_n912# 0.17683f
C2 a_256_n912# w_n1218_n1030# 0.1769f
C3 w_n1218_n1030# a_356_n820# 0.18233f
C4 a_n460_n820# w_n1218_n1030# 0.18233f
C5 a_256_n912# a_356_n820# 0.10645f
C6 w_n1218_n1030# a_152_n820# 0.18232f
C7 a_256_n912# a_152_n820# 0.10645f
C8 a_n1056_n820# a_n868_n820# 0.48137f
C9 a_152_n820# a_356_n820# 0.48137f
C10 a_n968_n912# a_n764_n912# 0.05997f
C11 a_n764_n912# a_n664_n820# 0.10645f
C12 w_n1218_n1030# a_n868_n820# 0.18238f
C13 a_n52_n820# a_n256_n820# 0.48137f
C14 a_n1056_n820# a_n968_n912# 0.10645f
C15 a_560_n820# a_664_n912# 0.10645f
C16 a_868_n912# a_968_n820# 0.10645f
C17 a_n560_n912# a_n764_n912# 0.05997f
C18 a_560_n820# a_460_n912# 0.10645f
C19 a_n560_n912# a_n664_n820# 0.10645f
C20 a_n52_n820# a_52_n912# 0.10645f
C21 a_n356_n912# a_n256_n820# 0.10645f
C22 a_764_n820# a_968_n820# 0.48137f
C23 a_560_n820# a_764_n820# 0.48137f
C24 a_n764_n912# w_n1218_n1030# 0.1775f
C25 w_n1218_n1030# a_968_n820# 0.9735f
C26 a_560_n820# w_n1218_n1030# 0.18234f
C27 a_n968_n912# w_n1218_n1030# 0.21652f
C28 a_560_n820# a_356_n820# 0.48137f
C29 w_n1218_n1030# a_n664_n820# 0.18234f
C30 a_868_n912# a_664_n912# 0.05997f
C31 w_n1218_n1030# a_n256_n820# 0.18232f
C32 a_n460_n820# a_n664_n820# 0.48137f
C33 a_n560_n912# a_n356_n912# 0.05997f
C34 a_n256_n820# a_n152_n912# 0.10645f
C35 w_n1218_n1030# a_n52_n820# 0.18232f
C36 a_664_n912# a_460_n912# 0.05997f
C37 a_n460_n820# a_n256_n820# 0.48137f
C38 a_n52_n820# a_n152_n912# 0.10645f
C39 a_764_n820# a_664_n912# 0.10645f
C40 a_764_n820# a_868_n912# 0.10645f
C41 a_152_n820# a_n52_n820# 0.48137f
C42 w_n1218_n1030# a_52_n912# 0.17683f
C43 a_n1056_n820# w_n1218_n1030# 0.9735f
C44 w_n1218_n1030# a_664_n912# 0.1775f
C45 a_868_n912# w_n1218_n1030# 0.21652f
C46 a_n152_n912# a_52_n912# 0.05997f
C47 a_256_n912# a_52_n912# 0.05997f
C48 a_n356_n912# w_n1218_n1030# 0.1769f
C49 a_n560_n912# w_n1218_n1030# 0.17701f
C50 a_n356_n912# a_n152_n912# 0.05997f
C51 a_n356_n912# a_n460_n820# 0.10645f
C52 a_152_n820# a_52_n912# 0.10645f
C53 a_n764_n912# a_n868_n820# 0.10645f
C54 w_n1218_n1030# a_460_n912# 0.17701f
C55 a_n560_n912# a_n460_n820# 0.10645f
C56 a_n968_n912# a_n868_n820# 0.10645f
C57 a_256_n912# a_460_n912# 0.05997f
C58 a_356_n820# a_460_n912# 0.10645f
C59 a_n868_n820# a_n664_n820# 0.48137f
C60 a_968_n820# VSUBS 0.04447f
C61 a_764_n820# VSUBS 0.07206f
C62 a_560_n820# VSUBS 0.06691f
C63 a_356_n820# VSUBS 0.06691f
C64 a_152_n820# VSUBS 0.06691f
C65 a_n52_n820# VSUBS 0.06691f
C66 a_n256_n820# VSUBS 0.06691f
C67 a_n460_n820# VSUBS 0.06691f
C68 a_n664_n820# VSUBS 0.06691f
C69 a_n868_n820# VSUBS 0.07206f
C70 a_n1056_n820# VSUBS 0.04447f
C71 w_n1218_n1030# VSUBS 15.6819f
.ends

.subckt nfet_03v3_TNDTXF a_n52_n500# a_n852_n500# a_356_n500# a_52_n592# a_560_n500#
+ a_n152_n592# a_152_n500# a_n664_n500# a_664_n592# a_n764_n592# a_n256_n500# a_n990_n686#
+ a_n460_n500# a_256_n592# a_764_n500# a_n356_n592# a_460_n592# a_n560_n592#
X0 a_560_n500# a_460_n592# a_356_n500# a_n990_n686# nfet_03v3 ad=1.3p pd=5.52u as=1.3p ps=5.52u w=5u l=0.5u
X1 a_n256_n500# a_n356_n592# a_n460_n500# a_n990_n686# nfet_03v3 ad=1.3p pd=5.52u as=1.3p ps=5.52u w=5u l=0.5u
X2 a_356_n500# a_256_n592# a_152_n500# a_n990_n686# nfet_03v3 ad=1.3p pd=5.52u as=1.3p ps=5.52u w=5u l=0.5u
X3 a_n664_n500# a_n764_n592# a_n852_n500# a_n990_n686# nfet_03v3 ad=1.3p pd=5.52u as=2.2p ps=10.88u w=5u l=0.5u
X4 a_152_n500# a_52_n592# a_n52_n500# a_n990_n686# nfet_03v3 ad=1.3p pd=5.52u as=1.3p ps=5.52u w=5u l=0.5u
X5 a_764_n500# a_664_n592# a_560_n500# a_n990_n686# nfet_03v3 ad=2.2p pd=10.88u as=1.3p ps=5.52u w=5u l=0.5u
X6 a_n460_n500# a_n560_n592# a_n664_n500# a_n990_n686# nfet_03v3 ad=1.3p pd=5.52u as=1.3p ps=5.52u w=5u l=0.5u
X7 a_n52_n500# a_n152_n592# a_n256_n500# a_n990_n686# nfet_03v3 ad=1.3p pd=5.52u as=1.3p ps=5.52u w=5u l=0.5u
C0 a_n560_n592# a_n356_n592# 0.05997f
C1 a_n560_n592# a_n664_n500# 0.06481f
C2 a_n852_n500# a_n664_n500# 0.29306f
C3 a_256_n592# a_152_n500# 0.06481f
C4 a_356_n500# a_256_n592# 0.06481f
C5 a_n256_n500# a_n356_n592# 0.06481f
C6 a_n152_n592# a_n52_n500# 0.06481f
C7 a_560_n500# a_356_n500# 0.29306f
C8 a_356_n500# a_152_n500# 0.29306f
C9 a_n52_n500# a_152_n500# 0.29306f
C10 a_560_n500# a_664_n592# 0.06481f
C11 a_n356_n592# a_n460_n500# 0.06481f
C12 a_n664_n500# a_n460_n500# 0.29306f
C13 a_n560_n592# a_n460_n500# 0.06481f
C14 a_52_n592# a_256_n592# 0.05997f
C15 a_n152_n592# a_52_n592# 0.05997f
C16 a_52_n592# a_152_n500# 0.06481f
C17 a_n256_n500# a_n460_n500# 0.29306f
C18 a_n152_n592# a_n356_n592# 0.05997f
C19 a_560_n500# a_764_n500# 0.29306f
C20 a_52_n592# a_n52_n500# 0.06481f
C21 a_764_n500# a_664_n592# 0.06481f
C22 a_256_n592# a_460_n592# 0.05997f
C23 a_n764_n592# a_n664_n500# 0.06481f
C24 a_n560_n592# a_n764_n592# 0.05997f
C25 a_n152_n592# a_n256_n500# 0.06481f
C26 a_560_n500# a_460_n592# 0.06481f
C27 a_n852_n500# a_n764_n592# 0.06481f
C28 a_356_n500# a_460_n592# 0.06481f
C29 a_664_n592# a_460_n592# 0.05997f
C30 a_n52_n500# a_n256_n500# 0.29306f
C31 a_764_n500# a_n990_n686# 0.6677f
C32 a_560_n500# a_n990_n686# 0.24078f
C33 a_356_n500# a_n990_n686# 0.2159f
C34 a_152_n500# a_n990_n686# 0.21558f
C35 a_n52_n500# a_n990_n686# 0.2155f
C36 a_n256_n500# a_n990_n686# 0.21558f
C37 a_n460_n500# a_n990_n686# 0.2159f
C38 a_n664_n500# a_n990_n686# 0.24078f
C39 a_n852_n500# a_n990_n686# 0.6677f
.ends

.subckt nfet_03v3_C4MKPC a_n52_n200# a_n862_n386# a_52_n292# a_636_n200# a_n396_n200#
+ a_396_n292# a_n724_n200# a_n292_n292# a_292_n200# a_n636_n292#
X0 a_n52_n200# a_n292_n292# a_n396_n200# a_n862_n386# nfet_03v3 ad=0.52p pd=2.52u as=0.52p ps=2.52u w=2u l=1.2u
X1 a_292_n200# a_52_n292# a_n52_n200# a_n862_n386# nfet_03v3 ad=0.52p pd=2.52u as=0.52p ps=2.52u w=2u l=1.2u
X2 a_636_n200# a_396_n292# a_292_n200# a_n862_n386# nfet_03v3 ad=0.88p pd=4.88u as=0.52p ps=2.52u w=2u l=1.2u
X3 a_n396_n200# a_n636_n292# a_n724_n200# a_n862_n386# nfet_03v3 ad=0.52p pd=2.52u as=0.88p ps=4.88u w=2u l=1.2u
C0 a_n724_n200# a_n396_n200# 0.06124f
C1 a_636_n200# a_396_n292# 0.04691f
C2 a_292_n200# a_396_n292# 0.04691f
C3 a_396_n292# a_52_n292# 0.05997f
C4 a_n636_n292# a_n396_n200# 0.04691f
C5 a_n52_n200# a_n396_n200# 0.06124f
C6 a_52_n292# a_n292_n292# 0.05997f
C7 a_n636_n292# a_n292_n292# 0.05997f
C8 a_n52_n200# a_n292_n292# 0.04691f
C9 a_636_n200# a_292_n200# 0.06124f
C10 a_292_n200# a_52_n292# 0.04691f
C11 a_n636_n292# a_n724_n200# 0.04691f
C12 a_n52_n200# a_292_n200# 0.06124f
C13 a_n292_n292# a_n396_n200# 0.04691f
C14 a_n52_n200# a_52_n292# 0.04691f
C15 a_636_n200# a_n862_n386# 0.69067f
C16 a_292_n200# a_n862_n386# 0.8969f
C17 a_n52_n200# a_n862_n386# 0.87089f
C18 a_n396_n200# a_n862_n386# 0.8969f
C19 a_n724_n200# a_n862_n386# 0.69067f
.ends

.subckt pfet_03v3_6BU64J a_292_n1676# a_n980_n1768# a_740_24# a_n1324_24# a_n1428_n1676#
+ a_1668_n1676# a_n1756_n1676# a_n980_24# a_980_n1676# a_n1084_n1676# a_52_24# a_n396_n1676#
+ a_n740_n1676# a_396_24# a_52_n1768# a_n636_24# a_n396_116# a_1428_24# a_n1084_116#
+ a_292_116# a_n1668_24# a_980_116# a_n740_116# a_1428_n1768# a_n1324_n1768# a_n52_116#
+ a_740_n1768# a_396_n1768# a_n636_n1768# w_n1918_n1886# a_1084_n1768# a_1668_116#
+ a_n1756_116# a_n292_n1768# a_n1428_116# a_n292_24# a_636_116# a_n1668_n1768# a_636_n1676#
+ a_n52_n1676# a_1324_116# a_1084_24# a_1324_n1676# VSUBS
X0 a_1324_116# a_1084_24# a_980_116# w_n1918_n1886# pfet_03v3 ad=2.028p pd=8.32u as=2.028p ps=8.32u w=7.8u l=1.2u
X1 a_n1428_n1676# a_n1668_n1768# a_n1756_n1676# w_n1918_n1886# pfet_03v3 ad=2.028p pd=8.32u as=3.432p ps=16.48u w=7.8u l=1.2u
X2 a_1668_116# a_1428_24# a_1324_116# w_n1918_n1886# pfet_03v3 ad=3.432p pd=16.48u as=2.028p ps=8.32u w=7.8u l=1.2u
X3 a_636_116# a_396_24# a_292_116# w_n1918_n1886# pfet_03v3 ad=2.028p pd=8.32u as=2.028p ps=8.32u w=7.8u l=1.2u
X4 a_980_116# a_740_24# a_636_116# w_n1918_n1886# pfet_03v3 ad=2.028p pd=8.32u as=2.028p ps=8.32u w=7.8u l=1.2u
X5 a_n1428_116# a_n1668_24# a_n1756_116# w_n1918_n1886# pfet_03v3 ad=2.028p pd=8.32u as=3.432p ps=16.48u w=7.8u l=1.2u
X6 a_n396_n1676# a_n636_n1768# a_n740_n1676# w_n1918_n1886# pfet_03v3 ad=2.028p pd=8.32u as=2.028p ps=8.32u w=7.8u l=1.2u
X7 a_n1084_116# a_n1324_24# a_n1428_116# w_n1918_n1886# pfet_03v3 ad=2.028p pd=8.32u as=2.028p ps=8.32u w=7.8u l=1.2u
X8 a_n52_n1676# a_n292_n1768# a_n396_n1676# w_n1918_n1886# pfet_03v3 ad=2.028p pd=8.32u as=2.028p ps=8.32u w=7.8u l=1.2u
X9 a_n740_116# a_n980_24# a_n1084_116# w_n1918_n1886# pfet_03v3 ad=2.028p pd=8.32u as=2.028p ps=8.32u w=7.8u l=1.2u
X10 a_n1084_n1676# a_n1324_n1768# a_n1428_n1676# w_n1918_n1886# pfet_03v3 ad=2.028p pd=8.32u as=2.028p ps=8.32u w=7.8u l=1.2u
X11 a_980_n1676# a_740_n1768# a_636_n1676# w_n1918_n1886# pfet_03v3 ad=2.028p pd=8.32u as=2.028p ps=8.32u w=7.8u l=1.2u
X12 a_n52_116# a_n292_24# a_n396_116# w_n1918_n1886# pfet_03v3 ad=2.028p pd=8.32u as=2.028p ps=8.32u w=7.8u l=1.2u
X13 a_292_n1676# a_52_n1768# a_n52_n1676# w_n1918_n1886# pfet_03v3 ad=2.028p pd=8.32u as=2.028p ps=8.32u w=7.8u l=1.2u
X14 a_n396_116# a_n636_24# a_n740_116# w_n1918_n1886# pfet_03v3 ad=2.028p pd=8.32u as=2.028p ps=8.32u w=7.8u l=1.2u
X15 a_292_116# a_52_24# a_n52_116# w_n1918_n1886# pfet_03v3 ad=2.028p pd=8.32u as=2.028p ps=8.32u w=7.8u l=1.2u
X16 a_1668_n1676# a_1428_n1768# a_1324_n1676# w_n1918_n1886# pfet_03v3 ad=3.432p pd=16.48u as=2.028p ps=8.32u w=7.8u l=1.2u
X17 a_636_n1676# a_396_n1768# a_292_n1676# w_n1918_n1886# pfet_03v3 ad=2.028p pd=8.32u as=2.028p ps=8.32u w=7.8u l=1.2u
X18 a_n740_n1676# a_n980_n1768# a_n1084_n1676# w_n1918_n1886# pfet_03v3 ad=2.028p pd=8.32u as=2.028p ps=8.32u w=7.8u l=1.2u
X19 a_1324_n1676# a_1084_n1768# a_980_n1676# w_n1918_n1886# pfet_03v3 ad=2.028p pd=8.32u as=2.028p ps=8.32u w=7.8u l=1.2u
C0 w_n1918_n1886# a_n1324_24# 0.57784f
C1 w_n1918_n1886# a_n52_116# 0.30563f
C2 w_n1918_n1886# a_n1756_n1676# 1.00127f
C3 a_396_24# a_52_24# 0.05997f
C4 w_n1918_n1886# a_1428_24# 0.61982f
C5 a_n1668_24# a_n1668_n1768# 0.22367f
C6 a_n1084_116# a_n740_116# 0.24064f
C7 a_396_n1768# a_292_n1676# 0.18432f
C8 w_n1918_n1886# a_1324_116# 0.30569f
C9 a_n636_24# a_n980_24# 0.05997f
C10 a_n1084_n1676# a_n740_n1676# 0.24064f
C11 a_n1428_116# a_n1756_116# 0.24064f
C12 a_n1668_24# w_n1918_n1886# 0.61982f
C13 a_n396_n1676# a_n292_n1768# 0.18432f
C14 a_396_n1768# a_740_n1768# 0.05997f
C15 a_n52_n1676# a_52_n1768# 0.18432f
C16 w_n1918_n1886# a_n292_n1768# 0.57633f
C17 a_1084_24# w_n1918_n1886# 0.57784f
C18 a_n980_24# a_n980_n1768# 0.22367f
C19 a_1324_116# a_1324_n1676# 0.0083f
C20 a_1084_n1768# a_740_n1768# 0.05997f
C21 a_1084_24# a_740_24# 0.05997f
C22 a_52_n1768# a_52_24# 0.22367f
C23 a_n1084_n1676# a_n980_n1768# 0.18432f
C24 a_n980_24# w_n1918_n1886# 0.57695f
C25 a_n1428_n1676# a_n1324_n1768# 0.18432f
C26 w_n1918_n1886# a_n1084_n1676# 0.30565f
C27 a_292_116# a_52_24# 0.18432f
C28 a_n1428_n1676# a_n1428_116# 0.0083f
C29 a_n1084_116# a_n1324_24# 0.18432f
C30 w_n1918_n1886# a_980_116# 0.30565f
C31 a_396_n1768# a_636_n1676# 0.18432f
C32 a_n52_116# a_292_116# 0.24064f
C33 w_n1918_n1886# a_396_n1768# 0.57665f
C34 a_740_24# a_980_116# 0.18432f
C35 a_1428_n1768# a_1428_24# 0.22367f
C36 a_n52_n1676# a_n52_116# 0.0083f
C37 w_n1918_n1886# a_1084_n1768# 0.57784f
C38 a_396_24# a_396_n1768# 0.22367f
C39 a_52_n1768# a_n292_n1768# 0.05997f
C40 a_636_116# a_980_116# 0.24064f
C41 a_n52_116# a_52_24# 0.18432f
C42 a_n1324_n1768# a_n1668_n1768# 0.05997f
C43 w_n1918_n1886# a_n1756_116# 1.00127f
C44 a_n1324_n1768# a_n980_n1768# 0.05997f
C45 a_n980_24# a_n740_116# 0.18432f
C46 a_n636_n1768# a_n292_n1768# 0.05997f
C47 a_1084_n1768# a_1324_n1676# 0.18432f
C48 w_n1918_n1886# a_n1324_n1768# 0.57784f
C49 a_n980_24# a_n1084_116# 0.18432f
C50 a_n292_24# a_n636_24# 0.05997f
C51 a_n52_n1676# a_n292_n1768# 0.18432f
C52 a_n1428_n1676# a_n1668_n1768# 0.18432f
C53 w_n1918_n1886# a_n1428_116# 0.30569f
C54 a_n1084_116# a_n1084_n1676# 0.0083f
C55 a_1324_116# a_1428_24# 0.18432f
C56 a_n292_24# a_n396_116# 0.18432f
C57 a_n1428_n1676# w_n1918_n1886# 0.30569f
C58 a_52_n1768# a_396_n1768# 0.05997f
C59 a_n1668_24# a_n1324_24# 0.05997f
C60 a_980_n1676# a_980_116# 0.0083f
C61 a_292_n1676# a_636_n1676# 0.24064f
C62 w_n1918_n1886# a_292_n1676# 0.30564f
C63 a_n292_24# w_n1918_n1886# 0.57633f
C64 a_1084_24# a_1428_24# 0.05997f
C65 a_740_n1768# a_636_n1676# 0.18432f
C66 a_n980_24# a_n1324_24# 0.05997f
C67 a_n636_24# a_n396_116# 0.18432f
C68 w_n1918_n1886# a_740_n1768# 0.57695f
C69 a_980_n1676# a_1084_n1768# 0.18432f
C70 a_n740_n1676# a_n980_n1768# 0.18432f
C71 a_1428_n1768# a_1084_n1768# 0.05997f
C72 w_n1918_n1886# a_1668_116# 1.00127f
C73 a_740_24# a_740_n1768# 0.22367f
C74 a_n740_n1676# a_n396_n1676# 0.24064f
C75 a_1668_n1676# a_1668_116# 0.0083f
C76 a_1084_24# a_1324_116# 0.18432f
C77 w_n1918_n1886# a_n740_n1676# 0.30564f
C78 a_n636_24# w_n1918_n1886# 0.57665f
C79 a_n396_n1676# a_n396_116# 0.0083f
C80 w_n1918_n1886# a_n396_116# 0.30564f
C81 w_n1918_n1886# a_n1668_n1768# 0.61982f
C82 w_n1918_n1886# a_n980_n1768# 0.57695f
C83 a_n1084_116# a_n1428_116# 0.24064f
C84 w_n1918_n1886# a_636_n1676# 0.30564f
C85 w_n1918_n1886# a_n396_n1676# 0.30564f
C86 a_1324_116# a_980_116# 0.24064f
C87 a_1668_n1676# w_n1918_n1886# 1.00127f
C88 a_52_n1768# a_292_n1676# 0.18432f
C89 w_n1918_n1886# a_740_24# 0.57695f
C90 a_292_116# a_292_n1676# 0.0083f
C91 w_n1918_n1886# a_396_24# 0.57665f
C92 a_1084_24# a_980_116# 0.18432f
C93 a_n1756_n1676# a_n1756_116# 0.0083f
C94 a_n1324_24# a_n1324_n1768# 0.22367f
C95 a_636_116# a_636_n1676# 0.0083f
C96 a_740_24# a_396_24# 0.05997f
C97 w_n1918_n1886# a_1324_n1676# 0.30569f
C98 w_n1918_n1886# a_636_116# 0.30564f
C99 a_1668_n1676# a_1324_n1676# 0.24064f
C100 a_980_n1676# a_740_n1768# 0.18432f
C101 a_n52_n1676# a_292_n1676# 0.24064f
C102 a_n740_n1676# a_n740_116# 0.0083f
C103 a_n1428_116# a_n1324_24# 0.18432f
C104 a_n636_24# a_n740_116# 0.18432f
C105 a_740_24# a_636_116# 0.18432f
C106 a_1084_24# a_1084_n1768# 0.22367f
C107 a_396_24# a_636_116# 0.18432f
C108 a_n396_116# a_n740_116# 0.24064f
C109 a_n292_24# a_52_24# 0.05997f
C110 a_n1668_24# a_n1756_116# 0.18432f
C111 a_n740_n1676# a_n636_n1768# 0.18432f
C112 a_n636_24# a_n636_n1768# 0.22367f
C113 a_n1428_n1676# a_n1756_n1676# 0.24064f
C114 w_n1918_n1886# a_n740_116# 0.30564f
C115 w_n1918_n1886# a_52_n1768# 0.57633f
C116 a_n292_24# a_n52_116# 0.18432f
C117 a_n1668_24# a_n1428_116# 0.18432f
C118 a_980_n1676# a_636_n1676# 0.24064f
C119 w_n1918_n1886# a_n1084_116# 0.30565f
C120 a_n636_n1768# a_n980_n1768# 0.05997f
C121 a_980_n1676# w_n1918_n1886# 0.30565f
C122 w_n1918_n1886# a_292_116# 0.30564f
C123 a_n396_n1676# a_n636_n1768# 0.18432f
C124 a_1428_n1768# w_n1918_n1886# 0.61982f
C125 w_n1918_n1886# a_n636_n1768# 0.57665f
C126 a_1428_n1768# a_1668_n1676# 0.18432f
C127 a_1668_116# a_1428_24# 0.18432f
C128 a_n52_n1676# a_n396_n1676# 0.24064f
C129 a_n1084_n1676# a_n1324_n1768# 0.18432f
C130 w_n1918_n1886# a_n52_n1676# 0.30563f
C131 a_396_24# a_292_116# 0.18432f
C132 a_n292_24# a_n292_n1768# 0.22367f
C133 a_1668_116# a_1324_116# 0.24064f
C134 a_980_n1676# a_1324_n1676# 0.24064f
C135 w_n1918_n1886# a_52_24# 0.57633f
C136 a_n396_116# a_n52_116# 0.24064f
C137 a_292_116# a_636_116# 0.24064f
C138 a_n1756_n1676# a_n1668_n1768# 0.18432f
C139 a_1428_n1768# a_1324_n1676# 0.18432f
C140 a_n1428_n1676# a_n1084_n1676# 0.24064f
C141 a_1668_n1676# VSUBS 0.02404f
C142 a_1324_n1676# VSUBS 0.04293f
C143 a_980_n1676# VSUBS 0.03777f
C144 a_636_n1676# VSUBS 0.03777f
C145 a_292_n1676# VSUBS 0.03777f
C146 a_n52_n1676# VSUBS 0.03777f
C147 a_n396_n1676# VSUBS 0.03777f
C148 a_n740_n1676# VSUBS 0.03777f
C149 a_n1084_n1676# VSUBS 0.03777f
C150 a_n1428_n1676# VSUBS 0.04293f
C151 a_n1756_n1676# VSUBS 0.02404f
C152 a_1668_116# VSUBS 0.02404f
C153 a_1324_116# VSUBS 0.04293f
C154 a_980_116# VSUBS 0.03777f
C155 a_636_116# VSUBS 0.03777f
C156 a_292_116# VSUBS 0.03777f
C157 a_n52_116# VSUBS 0.03777f
C158 a_n396_116# VSUBS 0.03777f
C159 a_n740_116# VSUBS 0.03777f
C160 a_n1084_116# VSUBS 0.03777f
C161 a_n1428_116# VSUBS 0.04293f
C162 a_n1756_116# VSUBS 0.02404f
C163 w_n1918_n1886# VSUBS 45.7966f
.ends

.subckt pfet_03v3_NRUA5E a_636_n838# a_n396_n838# a_n1324_n930# a_n292_n930# a_n636_n930#
+ a_740_n930# w_n1574_n1048# a_52_n930# a_1084_n930# a_396_n930# a_980_n838# a_n740_n838#
+ a_n1084_n838# a_292_n838# a_n52_n838# a_1324_n838# a_n1412_n838# a_n980_n930# VSUBS
X0 a_n396_n838# a_n636_n930# a_n740_n838# w_n1574_n1048# pfet_03v3 ad=2.1788p pd=8.9u as=2.1788p ps=8.9u w=8.38u l=1.2u
X1 a_n740_n838# a_n980_n930# a_n1084_n838# w_n1574_n1048# pfet_03v3 ad=2.1788p pd=8.9u as=2.1788p ps=8.9u w=8.38u l=1.2u
X2 a_n1084_n838# a_n1324_n930# a_n1412_n838# w_n1574_n1048# pfet_03v3 ad=2.1788p pd=8.9u as=3.6872p ps=17.64u w=8.38u l=1.2u
X3 a_n52_n838# a_n292_n930# a_n396_n838# w_n1574_n1048# pfet_03v3 ad=2.1788p pd=8.9u as=2.1788p ps=8.9u w=8.38u l=1.2u
X4 a_292_n838# a_52_n930# a_n52_n838# w_n1574_n1048# pfet_03v3 ad=2.1788p pd=8.9u as=2.1788p ps=8.9u w=8.38u l=1.2u
X5 a_636_n838# a_396_n930# a_292_n838# w_n1574_n1048# pfet_03v3 ad=2.1788p pd=8.9u as=2.1788p ps=8.9u w=8.38u l=1.2u
X6 a_980_n838# a_740_n930# a_636_n838# w_n1574_n1048# pfet_03v3 ad=2.1788p pd=8.9u as=2.1788p ps=8.9u w=8.38u l=1.2u
X7 a_1324_n838# a_1084_n930# a_980_n838# w_n1574_n1048# pfet_03v3 ad=3.6872p pd=17.64u as=2.1788p ps=8.9u w=8.38u l=1.2u
C0 a_636_n838# a_292_n838# 0.25858f
C1 w_n1574_n1048# a_980_n838# 0.34893f
C2 w_n1574_n1048# a_n740_n838# 0.3489f
C3 w_n1574_n1048# a_396_n930# 0.85023f
C4 a_n292_n930# a_52_n930# 0.05997f
C5 a_n52_n838# a_52_n930# 0.19805f
C6 a_980_n838# a_740_n930# 0.19805f
C7 a_n52_n838# a_292_n838# 0.25858f
C8 a_740_n930# a_396_n930# 0.05997f
C9 w_n1574_n1048# a_740_n930# 0.85112f
C10 a_1084_n930# a_1324_n838# 0.19805f
C11 a_n1084_n838# a_n1412_n838# 0.25858f
C12 a_52_n930# a_396_n930# 0.05997f
C13 w_n1574_n1048# a_52_n930# 0.84998f
C14 a_n292_n930# a_n396_n838# 0.19805f
C15 a_n396_n838# a_n636_n930# 0.19805f
C16 a_292_n838# a_396_n930# 0.19805f
C17 w_n1574_n1048# a_292_n838# 0.34889f
C18 a_n52_n838# a_n396_n838# 0.25858f
C19 a_n980_n930# a_n1084_n838# 0.19805f
C20 a_n1324_n930# a_n1412_n838# 0.19805f
C21 a_980_n838# a_1324_n838# 0.25858f
C22 a_636_n838# a_980_n838# 0.25858f
C23 a_n1084_n838# a_n1324_n930# 0.19805f
C24 w_n1574_n1048# a_1324_n838# 1.09419f
C25 a_636_n838# a_396_n930# 0.19805f
C26 a_636_n838# w_n1574_n1048# 0.3489f
C27 a_n396_n838# a_n740_n838# 0.25858f
C28 a_n292_n930# a_n636_n930# 0.05997f
C29 w_n1574_n1048# a_n396_n838# 0.34889f
C30 a_n636_n930# a_n980_n930# 0.05997f
C31 a_n52_n838# a_n292_n930# 0.19805f
C32 a_980_n838# a_1084_n930# 0.19805f
C33 w_n1574_n1048# a_n1412_n838# 1.09419f
C34 a_n980_n930# a_n1324_n930# 0.05997f
C35 a_n740_n838# a_n1084_n838# 0.25858f
C36 a_52_n930# a_292_n838# 0.19805f
C37 w_n1574_n1048# a_n1084_n838# 0.34893f
C38 w_n1574_n1048# a_1084_n930# 0.89309f
C39 a_636_n838# a_740_n930# 0.19805f
C40 a_n292_n930# w_n1574_n1048# 0.84998f
C41 a_n740_n838# a_n980_n930# 0.19805f
C42 a_n636_n930# a_n740_n838# 0.19805f
C43 w_n1574_n1048# a_n980_n930# 0.85112f
C44 w_n1574_n1048# a_n636_n930# 0.85023f
C45 a_n52_n838# w_n1574_n1048# 0.34889f
C46 a_1084_n930# a_740_n930# 0.05997f
C47 w_n1574_n1048# a_n1324_n930# 0.89309f
C48 a_1324_n838# VSUBS 0.0367f
C49 a_980_n838# VSUBS 0.06825f
C50 a_636_n838# VSUBS 0.0631f
C51 a_292_n838# VSUBS 0.0631f
C52 a_n52_n838# VSUBS 0.0631f
C53 a_n396_n838# VSUBS 0.0631f
C54 a_n740_n838# VSUBS 0.0631f
C55 a_n1084_n838# VSUBS 0.06825f
C56 a_n1412_n838# VSUBS 0.0367f
C57 w_n1574_n1048# VSUBS 21.4129f
.ends

.subckt nfet_03v3_ZTT4MX a_1428_n992# a_n980_n992# a_n1324_n992# a_n292_n992# a_n1894_n1086#
+ a_980_n900# a_n740_n900# a_n1668_n992# a_n1084_n900# a_292_n900# a_n636_n992# a_n52_n900#
+ a_740_n992# a_1324_n900# a_n1428_n900# a_n396_n900# a_52_n992# a_636_n900# a_1084_n992#
+ a_1668_n900# a_n1756_n900# a_396_n992#
X0 a_n52_n900# a_n292_n992# a_n396_n900# a_n1894_n1086# nfet_03v3 ad=2.34p pd=9.52u as=2.34p ps=9.52u w=9u l=1.2u
X1 a_n1428_n900# a_n1668_n992# a_n1756_n900# a_n1894_n1086# nfet_03v3 ad=2.34p pd=9.52u as=3.96p ps=18.88u w=9u l=1.2u
X2 a_292_n900# a_52_n992# a_n52_n900# a_n1894_n1086# nfet_03v3 ad=2.34p pd=9.52u as=2.34p ps=9.52u w=9u l=1.2u
X3 a_1668_n900# a_1428_n992# a_1324_n900# a_n1894_n1086# nfet_03v3 ad=3.96p pd=18.88u as=2.34p ps=9.52u w=9u l=1.2u
X4 a_636_n900# a_396_n992# a_292_n900# a_n1894_n1086# nfet_03v3 ad=2.34p pd=9.52u as=2.34p ps=9.52u w=9u l=1.2u
X5 a_980_n900# a_740_n992# a_636_n900# a_n1894_n1086# nfet_03v3 ad=2.34p pd=9.52u as=2.34p ps=9.52u w=9u l=1.2u
X6 a_1324_n900# a_1084_n992# a_980_n900# a_n1894_n1086# nfet_03v3 ad=2.34p pd=9.52u as=2.34p ps=9.52u w=9u l=1.2u
X7 a_n396_n900# a_n636_n992# a_n740_n900# a_n1894_n1086# nfet_03v3 ad=2.34p pd=9.52u as=2.34p ps=9.52u w=9u l=1.2u
X8 a_n740_n900# a_n980_n992# a_n1084_n900# a_n1894_n1086# nfet_03v3 ad=2.34p pd=9.52u as=2.34p ps=9.52u w=9u l=1.2u
X9 a_n1084_n900# a_n1324_n992# a_n1428_n900# a_n1894_n1086# nfet_03v3 ad=2.34p pd=9.52u as=2.34p ps=9.52u w=9u l=1.2u
C0 a_n740_n900# a_n396_n900# 0.27776f
C1 a_740_n992# a_980_n900# 0.21274f
C2 a_n1668_n992# a_n1756_n900# 0.21274f
C3 a_1084_n992# a_1428_n992# 0.05997f
C4 a_n292_n992# a_n396_n900# 0.21274f
C5 a_740_n992# a_1084_n992# 0.05997f
C6 a_396_n992# a_52_n992# 0.05997f
C7 a_636_n900# a_396_n992# 0.21274f
C8 a_n292_n992# a_52_n992# 0.05997f
C9 a_n1428_n900# a_n1324_n992# 0.21274f
C10 a_1324_n900# a_980_n900# 0.27776f
C11 a_n1084_n900# a_n1324_n992# 0.21274f
C12 a_n740_n900# a_n980_n992# 0.21274f
C13 a_1668_n900# a_1428_n992# 0.21274f
C14 a_980_n900# a_1084_n992# 0.21274f
C15 a_1324_n900# a_1084_n992# 0.21274f
C16 a_n1084_n900# a_n1428_n900# 0.27776f
C17 a_740_n992# a_396_n992# 0.05997f
C18 a_740_n992# a_636_n900# 0.21274f
C19 a_n52_n900# a_292_n900# 0.27776f
C20 a_n1668_n992# a_n1324_n992# 0.05997f
C21 a_n396_n900# a_n52_n900# 0.27776f
C22 a_n636_n992# a_n396_n900# 0.21274f
C23 a_n1668_n992# a_n1428_n900# 0.21274f
C24 a_1324_n900# a_1668_n900# 0.27776f
C25 a_n1756_n900# a_n1428_n900# 0.27776f
C26 a_636_n900# a_980_n900# 0.27776f
C27 a_n1324_n992# a_n980_n992# 0.05997f
C28 a_n52_n900# a_52_n992# 0.21274f
C29 a_n740_n900# a_n1084_n900# 0.27776f
C30 a_n740_n900# a_n636_n992# 0.21274f
C31 a_n292_n992# a_n52_n900# 0.21274f
C32 a_n292_n992# a_n636_n992# 0.05997f
C33 a_292_n900# a_396_n992# 0.21274f
C34 a_292_n900# a_52_n992# 0.21274f
C35 a_636_n900# a_292_n900# 0.27776f
C36 a_n1084_n900# a_n980_n992# 0.21274f
C37 a_n636_n992# a_n980_n992# 0.05997f
C38 a_1324_n900# a_1428_n992# 0.21274f
C39 a_1668_n900# a_n1894_n1086# 1.43999f
C40 a_1324_n900# a_n1894_n1086# 0.9147f
C41 a_980_n900# a_n1894_n1086# 0.88809f
C42 a_636_n900# a_n1894_n1086# 0.88748f
C43 a_292_n900# a_n1894_n1086# 0.88716f
C44 a_n52_n900# a_n1894_n1086# 0.887f
C45 a_n396_n900# a_n1894_n1086# 0.88716f
C46 a_n740_n900# a_n1894_n1086# 0.88748f
C47 a_n1084_n900# a_n1894_n1086# 0.88809f
C48 a_n1428_n900# a_n1894_n1086# 0.9147f
C49 a_n1756_n900# a_n1894_n1086# 1.43999f
.ends

.subckt nfet_03v3_93L8BL a_n1668_n520# a_n2460_n428# a_n636_n520# a_740_n520# a_2116_n520#
+ a_1772_n520# a_2700_n428# a_52_n520# a_1084_n520# a_n2700_n520# a_2012_n428# a_n2116_n428#
+ a_396_n520# a_n1772_n428# a_n2012_n520# a_980_n428# a_n740_n428# a_n1084_n428# a_2356_n428#
+ a_1428_n520# a_292_n428# a_n52_n428# a_n2356_n520# a_1324_n428# a_n2788_n428# a_n980_n520#
+ a_n1428_n428# a_636_n428# a_n396_n428# a_n1324_n520# a_n292_n520# a_2460_n520# a_1668_n428#
+ a_n2926_n614#
X0 a_n1772_n428# a_n2012_n520# a_n2116_n428# a_n2926_n614# nfet_03v3 ad=1.1128p pd=4.8u as=1.1128p ps=4.8u w=4.28u l=1.2u
X1 a_1668_n428# a_1428_n520# a_1324_n428# a_n2926_n614# nfet_03v3 ad=1.1128p pd=4.8u as=1.1128p ps=4.8u w=4.28u l=1.2u
X2 a_n2116_n428# a_n2356_n520# a_n2460_n428# a_n2926_n614# nfet_03v3 ad=1.1128p pd=4.8u as=1.1128p ps=4.8u w=4.28u l=1.2u
X3 a_n2460_n428# a_n2700_n520# a_n2788_n428# a_n2926_n614# nfet_03v3 ad=1.1128p pd=4.8u as=1.8832p ps=9.44u w=4.28u l=1.2u
X4 a_636_n428# a_396_n520# a_292_n428# a_n2926_n614# nfet_03v3 ad=1.1128p pd=4.8u as=1.1128p ps=4.8u w=4.28u l=1.2u
X5 a_980_n428# a_740_n520# a_636_n428# a_n2926_n614# nfet_03v3 ad=1.1128p pd=4.8u as=1.1128p ps=4.8u w=4.28u l=1.2u
X6 a_1324_n428# a_1084_n520# a_980_n428# a_n2926_n614# nfet_03v3 ad=1.1128p pd=4.8u as=1.1128p ps=4.8u w=4.28u l=1.2u
X7 a_2012_n428# a_1772_n520# a_1668_n428# a_n2926_n614# nfet_03v3 ad=1.1128p pd=4.8u as=1.1128p ps=4.8u w=4.28u l=1.2u
X8 a_n396_n428# a_n636_n520# a_n740_n428# a_n2926_n614# nfet_03v3 ad=1.1128p pd=4.8u as=1.1128p ps=4.8u w=4.28u l=1.2u
X9 a_n740_n428# a_n980_n520# a_n1084_n428# a_n2926_n614# nfet_03v3 ad=1.1128p pd=4.8u as=1.1128p ps=4.8u w=4.28u l=1.2u
X10 a_2356_n428# a_2116_n520# a_2012_n428# a_n2926_n614# nfet_03v3 ad=1.1128p pd=4.8u as=1.1128p ps=4.8u w=4.28u l=1.2u
X11 a_n1084_n428# a_n1324_n520# a_n1428_n428# a_n2926_n614# nfet_03v3 ad=1.1128p pd=4.8u as=1.1128p ps=4.8u w=4.28u l=1.2u
X12 a_n1428_n428# a_n1668_n520# a_n1772_n428# a_n2926_n614# nfet_03v3 ad=1.1128p pd=4.8u as=1.1128p ps=4.8u w=4.28u l=1.2u
X13 a_n52_n428# a_n292_n520# a_n396_n428# a_n2926_n614# nfet_03v3 ad=1.1128p pd=4.8u as=1.1128p ps=4.8u w=4.28u l=1.2u
X14 a_292_n428# a_52_n520# a_n52_n428# a_n2926_n614# nfet_03v3 ad=1.1128p pd=4.8u as=1.1128p ps=4.8u w=4.28u l=1.2u
X15 a_2700_n428# a_2460_n520# a_2356_n428# a_n2926_n614# nfet_03v3 ad=1.8832p pd=9.44u as=1.1128p ps=4.8u w=4.28u l=1.2u
C0 a_n1084_n428# a_n740_n428# 0.13177f
C1 a_n52_n428# a_52_n520# 0.10092f
C2 a_292_n428# a_636_n428# 0.13177f
C3 a_n2788_n428# a_n2700_n520# 0.10092f
C4 a_2700_n428# a_2356_n428# 0.13177f
C5 a_n52_n428# a_n396_n428# 0.13177f
C6 a_n1324_n520# a_n1084_n428# 0.10092f
C7 a_52_n520# a_396_n520# 0.05997f
C8 a_2700_n428# a_2460_n520# 0.10092f
C9 a_740_n520# a_396_n520# 0.05997f
C10 a_n1772_n428# a_n2012_n520# 0.10092f
C11 a_n1668_n520# a_n1772_n428# 0.10092f
C12 a_1324_n428# a_1668_n428# 0.13177f
C13 a_980_n428# a_740_n520# 0.10092f
C14 a_1428_n520# a_1668_n428# 0.10092f
C15 a_2012_n428# a_1668_n428# 0.13177f
C16 a_1084_n520# a_1324_n428# 0.10092f
C17 a_1084_n520# a_1428_n520# 0.05997f
C18 a_n636_n520# a_n740_n428# 0.10092f
C19 a_n1668_n520# a_n2012_n520# 0.05997f
C20 a_n1772_n428# a_n2116_n428# 0.13177f
C21 a_n1772_n428# a_n1428_n428# 0.13177f
C22 a_1428_n520# a_1324_n428# 0.10092f
C23 a_n636_n520# a_n292_n520# 0.05997f
C24 a_n2116_n428# a_n2012_n520# 0.10092f
C25 a_n740_n428# a_n396_n428# 0.13177f
C26 a_n292_n520# a_52_n520# 0.05997f
C27 a_n1668_n520# a_n1428_n428# 0.10092f
C28 a_292_n428# a_52_n520# 0.10092f
C29 a_740_n520# a_636_n428# 0.10092f
C30 a_2012_n428# a_2116_n520# 0.10092f
C31 a_n2460_n428# a_n2116_n428# 0.13177f
C32 a_n740_n428# a_n980_n520# 0.10092f
C33 a_n2460_n428# a_n2700_n520# 0.10092f
C34 a_1084_n520# a_740_n520# 0.05997f
C35 a_2356_n428# a_2012_n428# 0.13177f
C36 a_n292_n520# a_n396_n428# 0.10092f
C37 a_n52_n428# a_n292_n520# 0.10092f
C38 a_292_n428# a_n52_n428# 0.13177f
C39 a_2356_n428# a_2116_n520# 0.10092f
C40 a_n1324_n520# a_n980_n520# 0.05997f
C41 a_1772_n520# a_1668_n428# 0.10092f
C42 a_n1084_n428# a_n980_n520# 0.10092f
C43 a_n1668_n520# a_n1324_n520# 0.05997f
C44 a_2116_n520# a_2460_n520# 0.05997f
C45 a_396_n520# a_636_n428# 0.10092f
C46 a_292_n428# a_396_n520# 0.10092f
C47 a_n2356_n520# a_n2012_n520# 0.05997f
C48 a_2356_n428# a_2460_n520# 0.10092f
C49 a_980_n428# a_636_n428# 0.13177f
C50 a_1772_n520# a_1428_n520# 0.05997f
C51 a_1772_n520# a_2012_n428# 0.10092f
C52 a_n2460_n428# a_n2356_n520# 0.10092f
C53 a_n1324_n520# a_n1428_n428# 0.10092f
C54 a_1084_n520# a_980_n428# 0.10092f
C55 a_n1084_n428# a_n1428_n428# 0.13177f
C56 a_n2356_n520# a_n2116_n428# 0.10092f
C57 a_n636_n520# a_n396_n428# 0.10092f
C58 a_1772_n520# a_2116_n520# 0.05997f
C59 a_n2356_n520# a_n2700_n520# 0.05997f
C60 a_n2460_n428# a_n2788_n428# 0.13177f
C61 a_980_n428# a_1324_n428# 0.13177f
C62 a_n636_n520# a_n980_n520# 0.05997f
C63 a_2700_n428# a_n2926_n614# 0.934f
C64 a_2356_n428# a_n2926_n614# 0.90026f
C65 a_2012_n428# a_n2926_n614# 0.87365f
C66 a_1668_n428# a_n2926_n614# 0.87304f
C67 a_1324_n428# a_n2926_n614# 0.87272f
C68 a_980_n428# a_n2926_n614# 0.87253f
C69 a_636_n428# a_n2926_n614# 0.87249f
C70 a_292_n428# a_n2926_n614# 0.87249f
C71 a_n52_n428# a_n2926_n614# 0.87249f
C72 a_n396_n428# a_n2926_n614# 0.87249f
C73 a_n740_n428# a_n2926_n614# 0.87249f
C74 a_n1084_n428# a_n2926_n614# 0.87253f
C75 a_n1428_n428# a_n2926_n614# 0.87272f
C76 a_n1772_n428# a_n2926_n614# 0.87304f
C77 a_n2116_n428# a_n2926_n614# 0.87365f
C78 a_n2460_n428# a_n2926_n614# 0.90026f
C79 a_n2788_n428# a_n2926_n614# 0.934f
.ends

.subckt nfet_03v3_5FAP53 a_52_n168# a_n152_n168# a_152_n76# a_n240_n76# a_n52_n76#
+ VSUBS
X0 a_n52_n76# a_n152_n168# a_n240_n76# VSUBS nfet_03v3 ad=0.26p pd=1.52u as=0.44p ps=2.88u w=1u l=0.5u
X1 a_152_n76# a_52_n168# a_n52_n76# VSUBS nfet_03v3 ad=0.44p pd=2.88u as=0.26p ps=1.52u w=1u l=0.5u
C0 a_n52_n76# a_n240_n76# 0.05767f
C1 a_52_n168# a_n152_n168# 0.03518f
C2 a_52_n168# a_152_n76# 0.01275f
C3 a_52_n168# a_n52_n76# 0.01275f
C4 a_n152_n168# a_n52_n76# 0.01275f
C5 a_152_n76# a_n52_n76# 0.05767f
C6 a_n152_n168# a_n240_n76# 0.01275f
C7 a_152_n76# VSUBS 0.14655f
C8 a_n52_n76# VSUBS 0.19961f
C9 a_n240_n76# VSUBS 0.14655f
.ends

.subckt nfet_03v3_H6E8H4 a_52_n168# a_n152_n168# a_152_n76# a_n240_n76# a_n52_n76#
+ a_n378_n262#
X0 a_n52_n76# a_n152_n168# a_n240_n76# a_n378_n262# nfet_03v3 ad=0.26p pd=1.52u as=0.44p ps=2.88u w=1u l=0.5u
X1 a_152_n76# a_52_n168# a_n52_n76# a_n378_n262# nfet_03v3 ad=0.44p pd=2.88u as=0.26p ps=1.52u w=1u l=0.5u
C0 a_n52_n76# a_n240_n76# 0.05767f
C1 a_52_n168# a_n152_n168# 0.03518f
C2 a_52_n168# a_152_n76# 0.01275f
C3 a_52_n168# a_n52_n76# 0.01275f
C4 a_n152_n168# a_n52_n76# 0.01275f
C5 a_152_n76# a_n52_n76# 0.05767f
C6 a_n152_n168# a_n240_n76# 0.01275f
C7 a_152_n76# a_n378_n262# 0.21769f
C8 a_n52_n76# a_n378_n262# 0.20999f
C9 a_n240_n76# a_n378_n262# 0.21769f
.ends

.subckt pfet_03v3_KDKZ8D a_1668_n1636# a_980_n1636# a_n1084_n1636# a_740_24# a_n1324_24#
+ a_n396_n1636# a_n740_n1636# a_52_n1728# a_n980_24# a_52_24# a_396_24# a_n636_24#
+ a_n396_116# a_1428_24# a_1428_n1728# a_n1324_n1728# a_n1084_116# a_740_n1728# a_396_n1728#
+ a_n636_n1728# a_292_116# a_n1668_24# w_n1918_n1846# a_1084_n1728# a_n292_n1728#
+ a_980_116# a_n740_116# a_n52_116# a_636_n1636# a_n52_n1636# a_n1668_n1728# a_1324_n1636#
+ a_1668_116# a_n1756_116# a_292_n1636# a_n980_n1728# a_n1428_116# a_n292_24# a_636_116#
+ a_n1428_n1636# a_1324_116# a_1084_24# a_n1756_n1636# VSUBS
X0 a_1668_n1636# a_1428_n1728# a_1324_n1636# w_n1918_n1846# pfet_03v3 ad=3.344p pd=16.08u as=1.976p ps=8.12u w=7.6u l=1.2u
X1 a_1324_116# a_1084_24# a_980_116# w_n1918_n1846# pfet_03v3 ad=1.976p pd=8.12u as=1.976p ps=8.12u w=7.6u l=1.2u
X2 a_636_n1636# a_396_n1728# a_292_n1636# w_n1918_n1846# pfet_03v3 ad=1.976p pd=8.12u as=1.976p ps=8.12u w=7.6u l=1.2u
X3 a_1668_116# a_1428_24# a_1324_116# w_n1918_n1846# pfet_03v3 ad=3.344p pd=16.08u as=1.976p ps=8.12u w=7.6u l=1.2u
X4 a_n740_n1636# a_n980_n1728# a_n1084_n1636# w_n1918_n1846# pfet_03v3 ad=1.976p pd=8.12u as=1.976p ps=8.12u w=7.6u l=1.2u
X5 a_1324_n1636# a_1084_n1728# a_980_n1636# w_n1918_n1846# pfet_03v3 ad=1.976p pd=8.12u as=1.976p ps=8.12u w=7.6u l=1.2u
X6 a_636_116# a_396_24# a_292_116# w_n1918_n1846# pfet_03v3 ad=1.976p pd=8.12u as=1.976p ps=8.12u w=7.6u l=1.2u
X7 a_980_116# a_740_24# a_636_116# w_n1918_n1846# pfet_03v3 ad=1.976p pd=8.12u as=1.976p ps=8.12u w=7.6u l=1.2u
X8 a_n1428_116# a_n1668_24# a_n1756_116# w_n1918_n1846# pfet_03v3 ad=1.976p pd=8.12u as=3.344p ps=16.08u w=7.6u l=1.2u
X9 a_n1428_n1636# a_n1668_n1728# a_n1756_n1636# w_n1918_n1846# pfet_03v3 ad=1.976p pd=8.12u as=3.344p ps=16.08u w=7.6u l=1.2u
X10 a_n1084_116# a_n1324_24# a_n1428_116# w_n1918_n1846# pfet_03v3 ad=1.976p pd=8.12u as=1.976p ps=8.12u w=7.6u l=1.2u
X11 a_n740_116# a_n980_24# a_n1084_116# w_n1918_n1846# pfet_03v3 ad=1.976p pd=8.12u as=1.976p ps=8.12u w=7.6u l=1.2u
X12 a_n396_n1636# a_n636_n1728# a_n740_n1636# w_n1918_n1846# pfet_03v3 ad=1.976p pd=8.12u as=1.976p ps=8.12u w=7.6u l=1.2u
X13 a_n52_116# a_n292_24# a_n396_116# w_n1918_n1846# pfet_03v3 ad=1.976p pd=8.12u as=1.976p ps=8.12u w=7.6u l=1.2u
X14 a_n52_n1636# a_n292_n1728# a_n396_n1636# w_n1918_n1846# pfet_03v3 ad=1.976p pd=8.12u as=1.976p ps=8.12u w=7.6u l=1.2u
X15 a_n396_116# a_n636_24# a_n740_116# w_n1918_n1846# pfet_03v3 ad=1.976p pd=8.12u as=1.976p ps=8.12u w=7.6u l=1.2u
X16 a_292_116# a_52_24# a_n52_116# w_n1918_n1846# pfet_03v3 ad=1.976p pd=8.12u as=1.976p ps=8.12u w=7.6u l=1.2u
X17 a_n1084_n1636# a_n1324_n1728# a_n1428_n1636# w_n1918_n1846# pfet_03v3 ad=1.976p pd=8.12u as=1.976p ps=8.12u w=7.6u l=1.2u
X18 a_980_n1636# a_740_n1728# a_636_n1636# w_n1918_n1846# pfet_03v3 ad=1.976p pd=8.12u as=1.976p ps=8.12u w=7.6u l=1.2u
X19 a_292_n1636# a_52_n1728# a_n52_n1636# w_n1918_n1846# pfet_03v3 ad=1.976p pd=8.12u as=1.976p ps=8.12u w=7.6u l=1.2u
C0 a_n1084_116# a_n740_116# 0.23446f
C1 a_n1756_n1636# a_n1756_116# 0.0083f
C2 a_n52_116# a_52_24# 0.17958f
C3 w_n1918_n1846# a_n1084_116# 0.29845f
C4 a_292_n1636# a_52_n1728# 0.17958f
C5 a_n980_24# a_n1324_24# 0.05997f
C6 a_n636_n1728# a_n292_n1728# 0.05997f
C7 w_n1918_n1846# a_n292_24# 0.57623f
C8 w_n1918_n1846# a_n52_n1636# 0.29842f
C9 a_n396_n1636# a_n52_n1636# 0.23446f
C10 w_n1918_n1846# a_292_116# 0.29843f
C11 a_1428_24# a_1668_116# 0.17958f
C12 a_396_24# a_636_116# 0.17958f
C13 a_n740_116# a_n740_n1636# 0.0083f
C14 a_980_n1636# a_740_n1728# 0.17958f
C15 a_396_n1728# a_396_24# 0.22367f
C16 a_n980_n1728# a_n740_n1636# 0.17958f
C17 a_n1084_116# a_n1428_116# 0.23446f
C18 a_1084_n1728# a_1324_n1636# 0.17958f
C19 w_n1918_n1846# a_n740_n1636# 0.29843f
C20 a_n740_n1636# a_n396_n1636# 0.23446f
C21 a_1084_24# a_980_116# 0.17958f
C22 a_n52_116# a_n292_24# 0.17958f
C23 a_n52_n1636# a_52_n1728# 0.17958f
C24 a_1324_116# a_1428_24# 0.17958f
C25 a_n52_116# a_n52_n1636# 0.0083f
C26 a_n396_116# a_n292_24# 0.17958f
C27 w_n1918_n1846# a_1428_24# 0.61972f
C28 a_n1084_n1636# a_n1428_n1636# 0.23446f
C29 a_n292_24# a_n636_24# 0.05997f
C30 a_n1084_116# a_n980_24# 0.17958f
C31 a_1428_n1728# a_1428_24# 0.22367f
C32 a_n52_116# a_292_116# 0.23446f
C33 a_396_24# a_52_24# 0.05997f
C34 a_n292_24# a_n292_n1728# 0.22367f
C35 a_n292_n1728# a_n52_n1636# 0.17958f
C36 a_n1756_n1636# a_n1428_n1636# 0.23446f
C37 a_1084_n1728# a_980_n1636# 0.17958f
C38 a_980_n1636# a_1324_n1636# 0.23446f
C39 a_1668_n1636# a_1324_n1636# 0.23446f
C40 a_396_n1728# a_292_n1636# 0.17958f
C41 a_1084_24# a_1428_24# 0.05997f
C42 a_980_116# a_636_116# 0.23446f
C43 a_740_24# w_n1918_n1846# 0.57685f
C44 a_n1084_116# a_n1084_n1636# 0.0083f
C45 a_1324_116# a_1668_116# 0.23446f
C46 a_396_24# a_292_116# 0.17958f
C47 a_292_116# a_636_116# 0.23446f
C48 a_n1668_24# w_n1918_n1846# 0.61972f
C49 w_n1918_n1846# a_1668_116# 0.97617f
C50 a_n980_n1728# a_n1324_n1728# 0.05997f
C51 w_n1918_n1846# a_n1324_n1728# 0.57774f
C52 a_n1084_116# a_n1324_24# 0.17958f
C53 a_980_116# a_980_n1636# 0.0083f
C54 w_n1918_n1846# a_n740_116# 0.29843f
C55 w_n1918_n1846# a_1324_116# 0.29848f
C56 a_n740_n1636# a_n1084_n1636# 0.23446f
C57 w_n1918_n1846# a_n980_n1728# 0.57685f
C58 w_n1918_n1846# a_n396_n1636# 0.29843f
C59 a_n292_24# a_52_24# 0.05997f
C60 w_n1918_n1846# a_1428_n1728# 0.61972f
C61 a_1084_24# a_740_24# 0.05997f
C62 a_n1668_24# a_n1428_116# 0.17958f
C63 a_n636_n1728# a_n740_n1636# 0.17958f
C64 a_n1668_24# a_n1668_n1728# 0.22367f
C65 a_52_24# a_292_116# 0.17958f
C66 w_n1918_n1846# a_636_n1636# 0.29843f
C67 a_n52_n1636# a_292_n1636# 0.23446f
C68 a_n1668_24# a_n1756_116# 0.17958f
C69 a_740_24# a_740_n1728# 0.22367f
C70 a_n1668_n1728# a_n1324_n1728# 0.05997f
C71 a_292_116# a_292_n1636# 0.0083f
C72 w_n1918_n1846# a_52_n1728# 0.57623f
C73 a_n396_116# a_n740_116# 0.23446f
C74 a_n52_116# w_n1918_n1846# 0.29842f
C75 w_n1918_n1846# a_n1428_116# 0.29848f
C76 a_n636_24# a_n740_116# 0.17958f
C77 a_n1668_n1728# w_n1918_n1846# 0.61972f
C78 a_n396_116# w_n1918_n1846# 0.29843f
C79 a_n396_116# a_n396_n1636# 0.0083f
C80 w_n1918_n1846# a_n636_24# 0.57655f
C81 w_n1918_n1846# a_n1756_116# 0.97617f
C82 a_1084_24# a_1324_116# 0.17958f
C83 a_n740_116# a_n980_24# 0.17958f
C84 a_n980_n1728# a_n980_24# 0.22367f
C85 a_1084_24# w_n1918_n1846# 0.57774f
C86 w_n1918_n1846# a_n980_24# 0.57685f
C87 w_n1918_n1846# a_740_n1728# 0.57685f
C88 w_n1918_n1846# a_n292_n1728# 0.57623f
C89 a_n292_n1728# a_n396_n1636# 0.17958f
C90 a_740_24# a_396_24# 0.05997f
C91 a_740_24# a_636_116# 0.17958f
C92 a_n52_116# a_n396_116# 0.23446f
C93 a_n1428_116# a_n1756_116# 0.23446f
C94 a_636_n1636# a_740_n1728# 0.17958f
C95 a_n396_116# a_n636_24# 0.17958f
C96 a_n292_n1728# a_52_n1728# 0.05997f
C97 a_n636_24# a_n980_24# 0.05997f
C98 a_n1324_n1728# a_n1084_n1636# 0.17958f
C99 a_1324_116# a_1324_n1636# 0.0083f
C100 a_396_24# w_n1918_n1846# 0.57655f
C101 a_n1324_n1728# a_n1428_n1636# 0.17958f
C102 w_n1918_n1846# a_636_116# 0.29843f
C103 a_396_n1728# w_n1918_n1846# 0.57655f
C104 a_n980_n1728# a_n1084_n1636# 0.17958f
C105 a_1084_n1728# w_n1918_n1846# 0.57774f
C106 w_n1918_n1846# a_1324_n1636# 0.29848f
C107 w_n1918_n1846# a_n1084_n1636# 0.29845f
C108 a_1084_n1728# a_1428_n1728# 0.05997f
C109 a_n1668_24# a_n1324_24# 0.05997f
C110 a_1428_n1728# a_1324_n1636# 0.17958f
C111 w_n1918_n1846# a_n1428_n1636# 0.29848f
C112 a_n1324_n1728# a_n1324_24# 0.22367f
C113 a_636_n1636# a_636_116# 0.0083f
C114 a_n636_n1728# a_n980_n1728# 0.05997f
C115 a_396_n1728# a_636_n1636# 0.17958f
C116 w_n1918_n1846# a_n636_n1728# 0.57655f
C117 a_n636_n1728# a_n396_n1636# 0.17958f
C118 a_740_24# a_980_116# 0.17958f
C119 a_1668_n1636# a_1668_116# 0.0083f
C120 a_396_n1728# a_52_n1728# 0.05997f
C121 w_n1918_n1846# a_n1756_n1636# 0.97617f
C122 w_n1918_n1846# a_n1324_24# 0.57774f
C123 w_n1918_n1846# a_52_24# 0.57623f
C124 a_n1428_116# a_n1428_n1636# 0.0083f
C125 w_n1918_n1846# a_980_n1636# 0.29845f
C126 a_n1668_n1728# a_n1428_n1636# 0.17958f
C127 a_1084_24# a_1084_n1728# 0.22367f
C128 w_n1918_n1846# a_1668_n1636# 0.97617f
C129 w_n1918_n1846# a_292_n1636# 0.29843f
C130 a_1428_n1728# a_1668_n1636# 0.17958f
C131 a_1324_116# a_980_116# 0.23446f
C132 a_396_n1728# a_740_n1728# 0.05997f
C133 a_1084_n1728# a_740_n1728# 0.05997f
C134 a_n636_n1728# a_n636_24# 0.22367f
C135 a_n1428_116# a_n1324_24# 0.17958f
C136 a_636_n1636# a_980_n1636# 0.23446f
C137 a_n1668_n1728# a_n1756_n1636# 0.17958f
C138 w_n1918_n1846# a_980_116# 0.29845f
C139 a_52_24# a_52_n1728# 0.22367f
C140 a_636_n1636# a_292_n1636# 0.23446f
C141 a_1668_n1636# VSUBS 0.01781f
C142 a_1324_n1636# VSUBS 0.03047f
C143 a_980_n1636# VSUBS 0.02532f
C144 a_636_n1636# VSUBS 0.02532f
C145 a_292_n1636# VSUBS 0.02532f
C146 a_n52_n1636# VSUBS 0.02532f
C147 a_n396_n1636# VSUBS 0.02532f
C148 a_n740_n1636# VSUBS 0.02532f
C149 a_n1084_n1636# VSUBS 0.02532f
C150 a_n1428_n1636# VSUBS 0.03047f
C151 a_n1756_n1636# VSUBS 0.01781f
C152 a_1668_116# VSUBS 0.01781f
C153 a_1324_116# VSUBS 0.03047f
C154 a_980_116# VSUBS 0.02532f
C155 a_636_116# VSUBS 0.02532f
C156 a_292_116# VSUBS 0.02532f
C157 a_n52_116# VSUBS 0.02532f
C158 a_n396_116# VSUBS 0.02532f
C159 a_n740_116# VSUBS 0.02532f
C160 a_n1084_116# VSUBS 0.02532f
C161 a_n1428_116# VSUBS 0.03047f
C162 a_n1756_116# VSUBS 0.01781f
C163 w_n1918_n1846# VSUBS 44.8488f
.ends

.subckt comparator_3v3 VDDH Vip Vin VBN1 VBP1 OUT VSS
XXM12 VSS net7 net7 VSS VSS net7 net7 VSS net7 net7 VSS net7 net7 net7 nfet_03v3_YWK8CE
XXM13 vwp VDDH vwp vwp vwp VDDH vxn vwp VDDH VDDH vwp vxn vwp vxn vxn VDDH vwp vxn
+ vwp VDDH VDDH vwp VSS pfet_03v3_LN29N7
XXM14 VBP1 net4 net4 VBP1 VBP1 VBP1 VDDH VBP1 VBP1 VBP1 VBP1 VBP1 net4 net4 VDDH net4
+ VDDH net4 VBP1 VBP1 VBP1 VBP1 VBP1 VBP1 VDDH VDDH VDDH net4 VBP1 VBP1 VBP1 VBP1
+ VBP1 VBP1 net4 VBP1 VDDH VDDH VBP1 VDDH VDDH VBP1 VDDH VDDH VBP1 VDDH VBP1 net4
+ VBP1 net4 VBP1 VBP1 VBP1 VBP1 VBP1 VBP1 net4 VBP1 net4 VDDH VBP1 net4 VBP1 VBP1
+ VDDH net4 VBP1 VDDH VDDH net4 net4 net4 net4 net4 net4 VBP1 net4 VDDH VBP1 VDDH
+ net4 VBP1 VBP1 VBP1 net4 VBP1 VBP1 VBP1 VBP1 VBP1 VDDH net4 VBP1 VDDH VDDH VDDH
+ VBP1 VDDH VBP1 VDDH net4 net4 VDDH net4 net4 VDDH VDDH net4 VBP1 VBP1 VBP1 VBP1
+ VBP1 VDDH VBP1 VDDH VDDH net4 VBP1 VDDH VBP1 VDDH net4 VBP1 VBP1 VBP1 VBP1 net4
+ VBP1 VDDH VDDH VDDH VDDH VSS pfet_03v3_UB86XQ
XXM24 net8 net9 net9 net9 net8 net8 VDDH net8 net8 VDDH VDDH net8 net8 VDDH VDDH net8
+ VDDH VDDH net9 net8 net9 net8 VSS pfet_03v3_BXNJAZ
XXM25 VSS VSS VSS net8 net9 net8 net9 net9 net8 net8 net9 VSS VSS net8 VSS net8 net8
+ net8 nfet_03v3_TNDTXF
XXM26 net9 OUT OUT OUT net9 net9 VDDH net9 net9 VDDH VDDH net9 net9 VDDH VDDH net9
+ VDDH VDDH OUT net9 OUT net9 VSS pfet_03v3_BXNJAZ
XXM16 VSS VSS vxn VSS vxn vxn VSS vxn vxn vxn nfet_03v3_C4MKPC
XXM27 VSS VSS vxp VSS vxp vxp VSS vxp vxp vxp nfet_03v3_C4MKPC
XXM17 net4 Vip Vip Vip net2 net4 net4 Vip net4 net4 Vip net4 net2 Vip Vip Vip net4
+ Vip net4 net4 Vip net4 net2 Vip Vip net2 Vip Vip Vip VDDH Vip net4 net4 Vip net2
+ Vip net2 Vip net2 net2 net2 Vip net2 VSS pfet_03v3_6BU64J
XXM28 VSS VSS VSS net9 OUT net9 OUT OUT net9 net9 OUT VSS VSS net9 VSS net9 net9 net9
+ nfet_03v3_TNDTXF
XXM29 VDDH VWN VWN VWN VWN VWN VDDH VWN VWN VWN VWN VDDH VWN VWN VDDH VDDH VDDH VWN
+ VSS pfet_03v3_NRUA5E
XXM19 VSS net2 net2 VSS VSS net2 vwp VSS net2 vwp VSS net2 vwp net2 nfet_03v3_YWK8CE
XXM1 VDDH vwp vwp vwp vwp vwp VDDH vwp vwp vwp vwp VDDH vwp vwp VDDH VDDH VDDH vwp
+ VSS pfet_03v3_NRUA5E
Xnfet_03v3_TNDTXF_0 VSS VSS VSS net5 net8 net5 net8 net8 net5 net5 net8 VSS VSS net5
+ VSS net5 net5 net5 nfet_03v3_TNDTXF
XXM2 Vip Vip Vip Vip VSS VWN net1 Vip VWN VWN Vip net1 Vip net1 net1 VWN Vip net1
+ Vip VWN VWN Vip nfet_03v3_ZTT4MX
XXM3 VWN VDDH VWN VWN VWN VDDH vxp VWN VDDH VDDH VWN vxp VWN vxp vxp VDDH VWN vxp
+ VWN VDDH VDDH VWN VSS pfet_03v3_LN29N7
XXM4 Vin Vin Vin Vin VSS vwp net1 Vin vwp vwp Vin net1 Vin net1 net1 vwp Vin net1
+ Vin vwp vwp Vin nfet_03v3_ZTT4MX
XXM5 VSS net2 net2 VSS VSS net2 net2 VSS net2 net2 VSS net2 net2 net2 nfet_03v3_YWK8CE
XXM6 VBN1 net1 VBN1 VBN1 VBN1 VBN1 VSS VBN1 VBN1 VBN1 VSS VSS VBN1 net1 VBN1 net1
+ VSS net1 net1 VBN1 net1 VSS VBN1 VSS VSS VBN1 VSS VSS net1 VBN1 VBN1 VBN1 net1 VSS
+ nfet_03v3_93L8BL
XXM7 VBP1 net6 net6 VBP1 VBP1 VBP1 VDDH VBP1 VBP1 VBP1 VBP1 VBP1 net6 net6 VDDH net6
+ VDDH net6 VBP1 VBP1 VBP1 VBP1 VBP1 VBP1 VDDH VDDH VDDH net6 VBP1 VBP1 VBP1 VBP1
+ VBP1 VBP1 net6 VBP1 VDDH VDDH VBP1 VDDH VDDH VBP1 VDDH VDDH VBP1 VDDH VBP1 net6
+ VBP1 net6 VBP1 VBP1 VBP1 VBP1 VBP1 VBP1 net6 VBP1 net6 VDDH VBP1 net6 VBP1 VBP1
+ VDDH net6 VBP1 VDDH VDDH net6 net6 net6 net6 net6 net6 VBP1 net6 VDDH VBP1 VDDH
+ net6 VBP1 VBP1 VBP1 net6 VBP1 VBP1 VBP1 VBP1 VBP1 VDDH net6 VBP1 VDDH VDDH VDDH
+ VBP1 VDDH VBP1 VDDH net6 net6 VDDH net6 net6 VDDH VDDH net6 VBP1 VBP1 VBP1 VBP1
+ VBP1 VDDH VBP1 VDDH VDDH net6 VBP1 VDDH VBP1 VDDH net6 VBP1 VBP1 VBP1 VBP1 net6
+ VBP1 VDDH VDDH VDDH VDDH VSS pfet_03v3_UB86XQ
XXM8 VSS net3 net3 VSS VSS net3 VWN VSS net3 VWN VSS net3 VWN net3 nfet_03v3_YWK8CE
XXM9 net4 Vin Vin Vin net3 net4 net4 Vin net4 net4 Vin net4 net3 Vin Vin Vin net4
+ Vin net4 net4 Vin net4 net3 Vin Vin net3 Vin Vin Vin VDDH Vin net4 net4 Vin net3
+ Vin net3 Vin net3 net3 net3 Vin net3 VSS pfet_03v3_6BU64J
Xnfet_03v3_5FAP53_0 vxn vxn VSS VSS vxp VSS nfet_03v3_5FAP53
Xnfet_03v3_H6E8H4_0 vxp vxp VSS VSS vxn VSS nfet_03v3_H6E8H4
XXM20 net6 net6 net6 vxp vxp net6 net5 vxp vxp vxp vxp vxp net6 vxp vxp vxp net6 vxp
+ vxp vxp net6 vxp VDDH vxp vxp net6 net5 net5 net5 net5 vxp net5 net6 net6 net6 vxp
+ net5 vxp net5 net5 net5 vxp net6 VSS pfet_03v3_KDKZ8D
XXM10 net6 net6 net6 vxn vxn net6 net7 vxn vxn vxn vxn vxn net6 vxn vxn vxn net6 vxn
+ vxn vxn net6 vxn VDDH vxn vxn net6 net7 net7 net7 net7 vxn net7 net6 net6 net6 vxn
+ net7 vxn net7 net7 net7 vxn net6 VSS pfet_03v3_KDKZ8D
XXM21 net5 net8 net8 net8 net5 net5 VDDH net5 net5 VDDH VDDH net5 net5 VDDH VDDH net5
+ VDDH VDDH net8 net5 net8 net5 VSS pfet_03v3_BXNJAZ
XXM11 VSS net3 net3 VSS VSS net3 net3 VSS net3 net3 VSS net3 net3 net3 nfet_03v3_YWK8CE
XXM22 VSS net7 net7 VSS VSS net7 net5 VSS net7 net5 VSS net7 net5 net7 nfet_03v3_YWK8CE
C0 OUT net8 0
C1 VBP1 Vin 0.25264f
C2 net4 VBP1 4.41516f
C3 vxp vxn 1.56616f
C4 net7 VDDH 0.26881f
C5 vxn VBP1 0.33749f
C6 VDDH net9 1.5295f
C7 VDDH Vin 1.76948f
C8 VDDH net4 10.89426f
C9 Vip net2 1.87403f
C10 net3 VWN 0.36586f
C11 VDDH vxn 2.70035f
C12 net3 vwp 0.01959f
C13 VDDH net8 1.51174f
C14 net2 Vin 0.0175f
C15 net4 net2 3.13793f
C16 net7 net6 2.75634f
C17 VDDH OUT 0.68661f
C18 VBN1 VWN 0
C19 vxp VBP1 0.0696f
C20 vwp VWN 1.90838f
C21 net6 vxn 2.61571f
C22 VBN1 vwp 0
C23 vxp VDDH 3.19186f
C24 net3 Vip 0.0139f
C25 VDDH VBP1 18.69322f
C26 net7 net5 0.31457f
C27 net5 net9 0.00132f
C28 net7 net3 0.00137f
C29 net3 Vin 1.86595f
C30 VWN Vip 0.97924f
C31 net3 net4 3.21225f
C32 net5 vxn 0.0056f
C33 VBN1 Vip 0.29502f
C34 net2 VBP1 0
C35 VWN net1 1.29378f
C36 vxp net6 2.34231f
C37 vwp Vip 0.44825f
C38 VBN1 net1 1.09461f
C39 net5 net8 0.68288f
C40 net6 VBP1 4.2938f
C41 VDDH net2 0.3717f
C42 vwp net1 1.72877f
C43 VDDH net6 9.27287f
C44 VWN Vin 0.18166f
C45 VWN net4 0.00369f
C46 VBN1 Vin 0.0577f
C47 VBN1 net4 0.00444f
C48 VWN vxn 0
C49 vwp Vin 1.75707f
C50 vwp net4 1.22514f
C51 vwp vxn 1.22918f
C52 net5 vxp 2.04466f
C53 net5 VBP1 0
C54 Vip net1 1.26286f
C55 net3 VBP1 0.00121f
C56 net5 VDDH 1.03006f
C57 VDDH net3 0.28399f
C58 Vip Vin 0.011f
C59 net4 Vip 2.29919f
C60 vxp VWN 1.69493f
C61 net1 Vin 1.43891f
C62 net4 net1 0
C63 VBN1 VBP1 0.06039f
C64 vxp vwp 0.16988f
C65 VDDH VWN 7.21776f
C66 vwp VBP1 0.15025f
C67 net3 net2 0.04379f
C68 VDDH VBN1 0.24823f
C69 net5 net6 2.74688f
C70 net4 Vin 2.17266f
C71 net7 vxn 1.9707f
C72 VDDH vwp 11.39733f
C73 vxn Vin 0
C74 net9 net8 0.71127f
C75 VWN net2 0.164f
C76 Vip VBP1 0.25709f
C77 net9 OUT 0.62632f
C78 vwp net2 0.30522f
C79 net1 VBP1 0.00106f
C80 VDDH Vip 3.20316f
C81 net7 vxp 0.08753f
C82 VDDH net1 0.7251f
C83 net7 VBP1 0
C84 VBN1 VSS 2.63954f
C85 vxn VSS 2.29159f
C86 VBP1 VSS 12.31789f
C87 net7 VSS 3.6944f
C88 net6 VSS 1.75753f
C89 net5 VSS 2.89365f
C90 vxp VSS 4.47227f
C91 net3 VSS 2.77903f
C92 Vin VSS 3.66498f
C93 VDDH VSS 3.66975f
C94 VWN VSS 9.13539f
C95 net1 VSS 4.18089f
C96 net8 VSS 1.63507f
C97 vwp VSS 8.75411f
C98 net2 VSS 2.807f
C99 net4 VSS 1.52016f
C100 Vip VSS 1.46019f
C101 OUT VSS 1.27326f
C102 net9 VSS 1.59324f
.ends
